*
* Copyright Dr. Dušan Grujić (dusan.grujic@etf.bg.ac.rs)
*
* Licensed under the Apache License, Version 2.0 (the "License");
* you may not use this file except in compliance with the License.
* You may obtain a copy of the License at
*
*    https://www.apache.org/licenses/LICENSE-2.0
*
* Unless required by applicable law or agreed to in writing, software
* distributed under the License is distributed on an "AS IS" BASIS,
* WITHOUT WARRANTIES OR CONDITIONS OF ANY KIND, either express or implied.
* See the License for the specific language governing permissions and
* limitations under the License.
*

****************************************
* Cell : AND2_D1
* Description : Two input AND gate
* Reduced truth table for output Y
* ┌─────┬─────┬─────┐
* │ A   │ B   │   Y │
* ├─────┼─────┼─────┤
* │ 1   │ 1   │   1 │
* ├─────┼─────┼─────┤
* │ 0   │ -   │   0 │
* ├─────┼─────┼─────┤
* │ -   │ 0   │   0 │
* └─────┴─────┴─────┘
****************************************
.SUBCKT AND2_D1 A B Y VDD VSS
*.PININFO A:I B:I Y:O VDD:B VSS:B
MN0 n0 A VSS VSS sg13_lv_nmos w=3.2e-07 l=1.3e-07 ng=1
MN1 n1 B n0 VSS sg13_lv_nmos w=3.2e-07 l=1.3e-07 ng=1
MP0 n1 A VDD VDD sg13_lv_pmos w=3.6e-07 l=1.3e-07 ng=1
MP1 n1 B VDD VDD sg13_lv_pmos w=3.6e-07 l=1.3e-07 ng=1
MN2 Y n1 VSS VSS sg13_lv_nmos w=6.4e-07 l=1.3e-07 ng=1
MP2 Y n1 VDD VDD sg13_lv_pmos w=9.8e-07 l=1.3e-07 ng=1
.ENDS

****************************************
* Cell : AND2_D2
* Description : Two input AND gate
* Reduced truth table for output Y
* ┌─────┬─────┬─────┐
* │ A   │ B   │   Y │
* ├─────┼─────┼─────┤
* │ 1   │ 1   │   1 │
* ├─────┼─────┼─────┤
* │ 0   │ -   │   0 │
* ├─────┼─────┼─────┤
* │ -   │ 0   │   0 │
* └─────┴─────┴─────┘
****************************************
.SUBCKT AND2_D2 A B Y VDD VSS
*.PININFO A:I B:I Y:O VDD:B VSS:B
MN0 n0 A VSS VSS sg13_lv_nmos w=5e-07 l=1.3e-07 ng=1
MN1 n1 B n0 VSS sg13_lv_nmos w=5e-07 l=1.3e-07 ng=1
MP0 n1 A VDD VDD sg13_lv_pmos w=5.5e-07 l=1.3e-07 ng=1
MP1 n1 B VDD VDD sg13_lv_pmos w=5.5e-07 l=1.3e-07 ng=1
MN2 Y n1 VSS VSS sg13_lv_nmos w=1.07e-06 l=1.3e-07 ng=1
MP2 Y n1 VDD VDD sg13_lv_pmos w=1.6e-06 l=1.3e-07 ng=1
.ENDS

****************************************
* Cell : AND2_D4
* Description : Two input AND gate
* Reduced truth table for output Y
* ┌─────┬─────┬─────┐
* │ A   │ B   │   Y │
* ├─────┼─────┼─────┤
* │ 1   │ 1   │   1 │
* ├─────┼─────┼─────┤
* │ 0   │ -   │   0 │
* ├─────┼─────┼─────┤
* │ -   │ 0   │   0 │
* └─────┴─────┴─────┘
****************************************
.SUBCKT AND2_D4 A B Y VDD VSS
*.PININFO A:I B:I Y:O VDD:B VSS:B
MN0 n0 A VSS VSS sg13_lv_nmos w=1e-06 l=1.3e-07 ng=1
MN1 n1 B n0 VSS sg13_lv_nmos w=1e-06 l=1.3e-07 ng=1
MP0 n1 A VDD VDD sg13_lv_pmos w=1.1e-06 l=1.3e-07 ng=1
MP1 n1 B VDD VDD sg13_lv_pmos w=1.1e-06 l=1.3e-07 ng=1
MN2 Y n1 VSS VSS sg13_lv_nmos w=2.14e-06 l=1.3e-07 ng=2
MP2 Y n1 VDD VDD sg13_lv_pmos w=3.2e-06 l=1.3e-07 ng=2
.ENDS

****************************************
* Cell : AND2_DL
* Description : Two input AND gate
* Reduced truth table for output Y
* ┌─────┬─────┬─────┐
* │ A   │ B   │   Y │
* ├─────┼─────┼─────┤
* │ 1   │ 1   │   1 │
* ├─────┼─────┼─────┤
* │ 0   │ -   │   0 │
* ├─────┼─────┼─────┤
* │ -   │ 0   │   0 │
* └─────┴─────┴─────┘
****************************************
.SUBCKT AND2_DL A B Y VDD VSS
*.PININFO A:I B:I Y:O VDD:B VSS:B
MN0 n0 A VSS VSS sg13_lv_nmos w=1.8e-07 l=1.3e-07 ng=1
MN1 n1 B n0 VSS sg13_lv_nmos w=1.8e-07 l=1.3e-07 ng=1
MP0 n1 A VDD VDD sg13_lv_pmos w=2e-07 l=1.3e-07 ng=1
MP1 n1 B VDD VDD sg13_lv_pmos w=2e-07 l=1.3e-07 ng=1
MN2 Y n1 VSS VSS sg13_lv_nmos w=3.2e-07 l=1.3e-07 ng=1
MP2 Y n1 VDD VDD sg13_lv_pmos w=4.9e-07 l=1.3e-07 ng=1
.ENDS

****************************************
* Cell : AND3_D1
* Description : Three input AND gate
* Reduced truth table for output Y
* ┌─────┬─────┬─────┬─────┐
* │ A   │ B   │ C   │   Y │
* ├─────┼─────┼─────┼─────┤
* │ 1   │ 1   │ 1   │   1 │
* ├─────┼─────┼─────┼─────┤
* │ 0   │ -   │ -   │   0 │
* ├─────┼─────┼─────┼─────┤
* │ -   │ 0   │ -   │   0 │
* ├─────┼─────┼─────┼─────┤
* │ -   │ -   │ 0   │   0 │
* └─────┴─────┴─────┴─────┘
****************************************
.SUBCKT AND3_D1 A B C Y VDD VSS
*.PININFO A:I B:I C:I Y:O VDD:B VSS:B
MN0 n0 C VSS VSS sg13_lv_nmos w=4.2e-07 l=1.3e-07 ng=1
MN1 n1 B n0 VSS sg13_lv_nmos w=4.2e-07 l=1.3e-07 ng=1
MN2 n2 A n1 VSS sg13_lv_nmos w=4.2e-07 l=1.3e-07 ng=1
MP0 n2 A VDD VDD sg13_lv_pmos w=3.8e-07 l=1.3e-07 ng=1
MP1 n2 B VDD VDD sg13_lv_pmos w=3.8e-07 l=1.3e-07 ng=1
MP2 n2 C VDD VDD sg13_lv_pmos w=3.8e-07 l=1.3e-07 ng=1
MN3 Y n2 VSS VSS sg13_lv_nmos w=6.4e-07 l=1.3e-07 ng=1
MP3 Y n2 VDD VDD sg13_lv_pmos w=9.8e-07 l=1.3e-07 ng=1
.ENDS

****************************************
* Cell : AND3_D2
* Description : Three input AND gate
* Reduced truth table for output Y
* ┌─────┬─────┬─────┬─────┐
* │ A   │ B   │ C   │   Y │
* ├─────┼─────┼─────┼─────┤
* │ 1   │ 1   │ 1   │   1 │
* ├─────┼─────┼─────┼─────┤
* │ 0   │ -   │ -   │   0 │
* ├─────┼─────┼─────┼─────┤
* │ -   │ 0   │ -   │   0 │
* ├─────┼─────┼─────┼─────┤
* │ -   │ -   │ 0   │   0 │
* └─────┴─────┴─────┴─────┘
****************************************
.SUBCKT AND3_D2 A B C Y VDD VSS
*.PININFO A:I B:I C:I Y:O VDD:B VSS:B
MN0 n0 C VSS VSS sg13_lv_nmos w=5e-07 l=1.3e-07 ng=1
MN1 n1 B n0 VSS sg13_lv_nmos w=5e-07 l=1.3e-07 ng=1
MN2 n2 A n1 VSS sg13_lv_nmos w=5e-07 l=1.3e-07 ng=1
MP0 n2 A VDD VDD sg13_lv_pmos w=4.5e-07 l=1.3e-07 ng=1
MP1 n2 B VDD VDD sg13_lv_pmos w=4.5e-07 l=1.3e-07 ng=1
MP2 n2 C VDD VDD sg13_lv_pmos w=4.5e-07 l=1.3e-07 ng=1
MN3 Y n2 VSS VSS sg13_lv_nmos w=1.07e-06 l=1.3e-07 ng=1
MP3 Y n2 VDD VDD sg13_lv_pmos w=1.6e-06 l=1.3e-07 ng=1
.ENDS

****************************************
* Cell : AND3_D4
* Description : Three input AND gate
* Reduced truth table for output Y
* ┌─────┬─────┬─────┬─────┐
* │ A   │ B   │ C   │   Y │
* ├─────┼─────┼─────┼─────┤
* │ 1   │ 1   │ 1   │   1 │
* ├─────┼─────┼─────┼─────┤
* │ 0   │ -   │ -   │   0 │
* ├─────┼─────┼─────┼─────┤
* │ -   │ 0   │ -   │   0 │
* ├─────┼─────┼─────┼─────┤
* │ -   │ -   │ 0   │   0 │
* └─────┴─────┴─────┴─────┘
****************************************
.SUBCKT AND3_D4 A B C Y VDD VSS
*.PININFO A:I B:I C:I Y:O VDD:B VSS:B
MN0 n0 C VSS VSS sg13_lv_nmos w=1e-06 l=1.3e-07 ng=1
MN1 n1 B n0 VSS sg13_lv_nmos w=1e-06 l=1.3e-07 ng=1
MN2 n2 A n1 VSS sg13_lv_nmos w=1e-06 l=1.3e-07 ng=1
MP0 n2 A VDD VDD sg13_lv_pmos w=8e-07 l=1.3e-07 ng=1
MP1 n2 B VDD VDD sg13_lv_pmos w=8e-07 l=1.3e-07 ng=1
MP2 n2 C VDD VDD sg13_lv_pmos w=8e-07 l=1.3e-07 ng=1
MN3 Y n2 VSS VSS sg13_lv_nmos w=2.14e-06 l=1.3e-07 ng=2
MP3 Y n2 VDD VDD sg13_lv_pmos w=3.2e-06 l=1.3e-07 ng=2
.ENDS

****************************************
* Cell : AND3_DL
* Description : Three input AND gate
* Reduced truth table for output Y
* ┌─────┬─────┬─────┬─────┐
* │ A   │ B   │ C   │   Y │
* ├─────┼─────┼─────┼─────┤
* │ 1   │ 1   │ 1   │   1 │
* ├─────┼─────┼─────┼─────┤
* │ 0   │ -   │ -   │   0 │
* ├─────┼─────┼─────┼─────┤
* │ -   │ 0   │ -   │   0 │
* ├─────┼─────┼─────┼─────┤
* │ -   │ -   │ 0   │   0 │
* └─────┴─────┴─────┴─────┘
****************************************
.SUBCKT AND3_DL A B C Y VDD VSS
*.PININFO A:I B:I C:I Y:O VDD:B VSS:B
MN0 n0 C VSS VSS sg13_lv_nmos w=3.3e-07 l=1.3e-07 ng=1
MN1 n1 B n0 VSS sg13_lv_nmos w=3.3e-07 l=1.3e-07 ng=1
MN2 n2 A n1 VSS sg13_lv_nmos w=3.3e-07 l=1.3e-07 ng=1
MP0 n2 A VDD VDD sg13_lv_pmos w=3e-07 l=1.3e-07 ng=1
MP1 n2 B VDD VDD sg13_lv_pmos w=3e-07 l=1.3e-07 ng=1
MP2 n2 C VDD VDD sg13_lv_pmos w=3e-07 l=1.3e-07 ng=1
MN3 Y n2 VSS VSS sg13_lv_nmos w=3.2e-07 l=1.3e-07 ng=1
MP3 Y n2 VDD VDD sg13_lv_pmos w=4.9e-07 l=1.3e-07 ng=1
.ENDS

****************************************
* Cell : AND4_D1
* Description : Four input AND gate
* Reduced truth table for output Y
* ┌─────┬─────┬─────┬─────┬─────┐
* │ A   │ B   │ C   │ D   │   Y │
* ├─────┼─────┼─────┼─────┼─────┤
* │ 1   │ 1   │ 1   │ 1   │   1 │
* ├─────┼─────┼─────┼─────┼─────┤
* │ 0   │ -   │ -   │ -   │   0 │
* ├─────┼─────┼─────┼─────┼─────┤
* │ -   │ 0   │ -   │ -   │   0 │
* ├─────┼─────┼─────┼─────┼─────┤
* │ -   │ -   │ 0   │ -   │   0 │
* ├─────┼─────┼─────┼─────┼─────┤
* │ -   │ -   │ -   │ 0   │   0 │
* └─────┴─────┴─────┴─────┴─────┘
****************************************
.SUBCKT AND4_D1 A B C D Y VDD VSS
*.PININFO A:I B:I C:I D:I Y:O VDD:B VSS:B
MN0 n0 D VSS VSS sg13_lv_nmos w=4.5e-07 l=1.3e-07 ng=1
MN1 n1 C n0 VSS sg13_lv_nmos w=4.5e-07 l=1.3e-07 ng=1
MN2 n2 B n1 VSS sg13_lv_nmos w=4.5e-07 l=1.3e-07 ng=1
MN3 n3 A n2 VSS sg13_lv_nmos w=4.5e-07 l=1.3e-07 ng=1
MP0 n3 A VDD VDD sg13_lv_pmos w=4e-07 l=1.3e-07 ng=1
MP1 n3 B VDD VDD sg13_lv_pmos w=4e-07 l=1.3e-07 ng=1
MP2 n3 C VDD VDD sg13_lv_pmos w=4e-07 l=1.3e-07 ng=1
MP3 n3 D VDD VDD sg13_lv_pmos w=4e-07 l=1.3e-07 ng=1
MN4 Y n3 VSS VSS sg13_lv_nmos w=6.4e-07 l=1.3e-07 ng=1
MP4 Y n3 VDD VDD sg13_lv_pmos w=9.8e-07 l=1.3e-07 ng=1
.ENDS

****************************************
* Cell : AND4_D2
* Description : Four input AND gate
* Reduced truth table for output Y
* ┌─────┬─────┬─────┬─────┬─────┐
* │ A   │ B   │ C   │ D   │   Y │
* ├─────┼─────┼─────┼─────┼─────┤
* │ 1   │ 1   │ 1   │ 1   │   1 │
* ├─────┼─────┼─────┼─────┼─────┤
* │ 0   │ -   │ -   │ -   │   0 │
* ├─────┼─────┼─────┼─────┼─────┤
* │ -   │ 0   │ -   │ -   │   0 │
* ├─────┼─────┼─────┼─────┼─────┤
* │ -   │ -   │ 0   │ -   │   0 │
* ├─────┼─────┼─────┼─────┼─────┤
* │ -   │ -   │ -   │ 0   │   0 │
* └─────┴─────┴─────┴─────┴─────┘
****************************************
.SUBCKT AND4_D2 A B C D Y VDD VSS
*.PININFO A:I B:I C:I D:I Y:O VDD:B VSS:B
MN0 n0 D VSS VSS sg13_lv_nmos w=7.5e-07 l=1.3e-07 ng=1
MN1 n1 C n0 VSS sg13_lv_nmos w=7.5e-07 l=1.3e-07 ng=1
MN2 n2 B n1 VSS sg13_lv_nmos w=7.5e-07 l=1.3e-07 ng=1
MN3 n3 A n2 VSS sg13_lv_nmos w=7.5e-07 l=1.3e-07 ng=1
MP0 n3 A VDD VDD sg13_lv_pmos w=6.5e-07 l=1.3e-07 ng=1
MP1 n3 B VDD VDD sg13_lv_pmos w=6.5e-07 l=1.3e-07 ng=1
MP2 n3 C VDD VDD sg13_lv_pmos w=6.5e-07 l=1.3e-07 ng=1
MP3 n3 D VDD VDD sg13_lv_pmos w=6.5e-07 l=1.3e-07 ng=1
MN4 Y n3 VSS VSS sg13_lv_nmos w=1.07e-06 l=1.3e-07 ng=1
MP4 Y n3 VDD VDD sg13_lv_pmos w=1.6e-06 l=1.3e-07 ng=1
.ENDS

****************************************
* Cell : AND4_D4
* Description : Four input AND gate
* Reduced truth table for output Y
* ┌─────┬─────┬─────┬─────┬─────┐
* │ A   │ B   │ C   │ D   │   Y │
* ├─────┼─────┼─────┼─────┼─────┤
* │ 1   │ 1   │ 1   │ 1   │   1 │
* ├─────┼─────┼─────┼─────┼─────┤
* │ 0   │ -   │ -   │ -   │   0 │
* ├─────┼─────┼─────┼─────┼─────┤
* │ -   │ 0   │ -   │ -   │   0 │
* ├─────┼─────┼─────┼─────┼─────┤
* │ -   │ -   │ 0   │ -   │   0 │
* ├─────┼─────┼─────┼─────┼─────┤
* │ -   │ -   │ -   │ 0   │   0 │
* └─────┴─────┴─────┴─────┴─────┘
****************************************
.SUBCKT AND4_D4 A B C D Y VDD VSS
*.PININFO A:I B:I C:I D:I Y:O VDD:B VSS:B
MN0 n0 D VSS VSS sg13_lv_nmos w=7.2e-07 l=1.3e-07 ng=1
MN1 n1 C n0 VSS sg13_lv_nmos w=7.2e-07 l=1.3e-07 ng=1
MN2 n2 B n1 VSS sg13_lv_nmos w=7.2e-07 l=1.3e-07 ng=1
MN3 n3 A n2 VSS sg13_lv_nmos w=7.2e-07 l=1.3e-07 ng=1
MP0 n3 A VDD VDD sg13_lv_pmos w=6.2e-07 l=1.3e-07 ng=1
MP1 n3 B VDD VDD sg13_lv_pmos w=6.2e-07 l=1.3e-07 ng=1
MP2 n3 C VDD VDD sg13_lv_pmos w=6.2e-07 l=1.3e-07 ng=1
MP3 n3 D VDD VDD sg13_lv_pmos w=6.2e-07 l=1.3e-07 ng=1
MN4 n4 D VSS VSS sg13_lv_nmos w=7.2e-07 l=1.3e-07 ng=1
MN5 n5 C n4 VSS sg13_lv_nmos w=7.2e-07 l=1.3e-07 ng=1
MN6 n6 B n5 VSS sg13_lv_nmos w=7.2e-07 l=1.3e-07 ng=1
MN7 n3 A n6 VSS sg13_lv_nmos w=7.2e-07 l=1.3e-07 ng=1
MP4 n3 A VDD VDD sg13_lv_pmos w=6.2e-07 l=1.3e-07 ng=1
MP5 n3 B VDD VDD sg13_lv_pmos w=6.2e-07 l=1.3e-07 ng=1
MP6 n3 C VDD VDD sg13_lv_pmos w=6.2e-07 l=1.3e-07 ng=1
MP7 n3 D VDD VDD sg13_lv_pmos w=6.2e-07 l=1.3e-07 ng=1
MN8 Y n3 VSS VSS sg13_lv_nmos w=2.14e-06 l=1.3e-07 ng=2
MP8 Y n3 VDD VDD sg13_lv_pmos w=3.2e-06 l=1.3e-07 ng=2
.ENDS

****************************************
* Cell : AND4_DL
* Description : Four input AND gate
* Reduced truth table for output Y
* ┌─────┬─────┬─────┬─────┬─────┐
* │ A   │ B   │ C   │ D   │   Y │
* ├─────┼─────┼─────┼─────┼─────┤
* │ 1   │ 1   │ 1   │ 1   │   1 │
* ├─────┼─────┼─────┼─────┼─────┤
* │ 0   │ -   │ -   │ -   │   0 │
* ├─────┼─────┼─────┼─────┼─────┤
* │ -   │ 0   │ -   │ -   │   0 │
* ├─────┼─────┼─────┼─────┼─────┤
* │ -   │ -   │ 0   │ -   │   0 │
* ├─────┼─────┼─────┼─────┼─────┤
* │ -   │ -   │ -   │ 0   │   0 │
* └─────┴─────┴─────┴─────┴─────┘
****************************************
.SUBCKT AND4_DL A B C D Y VDD VSS
*.PININFO A:I B:I C:I D:I Y:O VDD:B VSS:B
MN0 n0 D VSS VSS sg13_lv_nmos w=3.4e-07 l=1.3e-07 ng=1
MN1 n1 C n0 VSS sg13_lv_nmos w=3.4e-07 l=1.3e-07 ng=1
MN2 n2 B n1 VSS sg13_lv_nmos w=3.4e-07 l=1.3e-07 ng=1
MN3 n3 A n2 VSS sg13_lv_nmos w=3.4e-07 l=1.3e-07 ng=1
MP0 n3 A VDD VDD sg13_lv_pmos w=3e-07 l=1.3e-07 ng=1
MP1 n3 B VDD VDD sg13_lv_pmos w=3e-07 l=1.3e-07 ng=1
MP2 n3 C VDD VDD sg13_lv_pmos w=3e-07 l=1.3e-07 ng=1
MP3 n3 D VDD VDD sg13_lv_pmos w=3e-07 l=1.3e-07 ng=1
MN4 Y n3 VSS VSS sg13_lv_nmos w=3.2e-07 l=1.3e-07 ng=1
MP4 Y n3 VDD VDD sg13_lv_pmos w=4.9e-07 l=1.3e-07 ng=1
.ENDS

****************************************
* Cell : AO21_D1
* Description : AND-OR gate with two AND inputs and one direct OR input
* Reduced truth table for output Y
* ┌─────┬─────┬─────┬─────┐
* │ A   │ B   │ C   │   Y │
* ├─────┼─────┼─────┼─────┤
* │ -   │ -   │ 1   │   1 │
* ├─────┼─────┼─────┼─────┤
* │ 1   │ 1   │ -   │   1 │
* ├─────┼─────┼─────┼─────┤
* │ 0   │ -   │ 0   │   0 │
* ├─────┼─────┼─────┼─────┤
* │ -   │ 0   │ 0   │   0 │
* └─────┴─────┴─────┴─────┘
****************************************
.SUBCKT AO21_D1 A B C Y VDD VSS
*.PININFO A:I B:I C:I Y:O VDD:B VSS:B
MN0 n0 A VSS VSS sg13_lv_nmos w=3e-07 l=1.3e-07
MN1 n1 B n0 VSS sg13_lv_nmos w=3e-07 l=1.3e-07
MN2 n1 C VSS VSS sg13_lv_nmos w=2e-07 l=1.3e-07
MP0 n2 A VDD VDD sg13_lv_pmos w=4e-07 l=1.3e-07
MP1 n2 B VDD VDD sg13_lv_pmos w=4e-07 l=1.3e-07
MP2 n1 C n2 VDD sg13_lv_pmos w=4e-07 l=1.3e-07
MN3 Y n1 VSS VSS sg13_lv_nmos w=6.4e-07 l=1.3e-07 ng=1
MP3 Y n1 VDD VDD sg13_lv_pmos w=9.8e-07 l=1.3e-07 ng=1
.ENDS

****************************************
* Cell : AO21_D2
* Description : AND-OR gate with two AND inputs and one direct OR input
* Reduced truth table for output Y
* ┌─────┬─────┬─────┬─────┐
* │ A   │ B   │ C   │   Y │
* ├─────┼─────┼─────┼─────┤
* │ -   │ -   │ 1   │   1 │
* ├─────┼─────┼─────┼─────┤
* │ 1   │ 1   │ -   │   1 │
* ├─────┼─────┼─────┼─────┤
* │ 0   │ -   │ 0   │   0 │
* ├─────┼─────┼─────┼─────┤
* │ -   │ 0   │ 0   │   0 │
* └─────┴─────┴─────┴─────┘
****************************************
.SUBCKT AO21_D2 A B C Y VDD VSS
*.PININFO A:I B:I C:I Y:O VDD:B VSS:B
MN0 n0 A VSS VSS sg13_lv_nmos w=5e-07 l=1.3e-07
MN1 n1 B n0 VSS sg13_lv_nmos w=5e-07 l=1.3e-07
MN2 n1 C VSS VSS sg13_lv_nmos w=3e-07 l=1.3e-07
MP0 n2 A VDD VDD sg13_lv_pmos w=6e-07 l=1.3e-07
MP1 n2 B VDD VDD sg13_lv_pmos w=6e-07 l=1.3e-07
MP2 n1 C n2 VDD sg13_lv_pmos w=6e-07 l=1.3e-07
MN3 Y n1 VSS VSS sg13_lv_nmos w=1.07e-06 l=1.3e-07 ng=1
MP3 Y n1 VDD VDD sg13_lv_pmos w=1.6e-06 l=1.3e-07 ng=1
.ENDS

****************************************
* Cell : AO21_DL
* Description : AND-OR gate with two AND inputs and one direct OR input
* Reduced truth table for output Y
* ┌─────┬─────┬─────┬─────┐
* │ A   │ B   │ C   │   Y │
* ├─────┼─────┼─────┼─────┤
* │ -   │ -   │ 1   │   1 │
* ├─────┼─────┼─────┼─────┤
* │ 1   │ 1   │ -   │   1 │
* ├─────┼─────┼─────┼─────┤
* │ 0   │ -   │ 0   │   0 │
* ├─────┼─────┼─────┼─────┤
* │ -   │ 0   │ 0   │   0 │
* └─────┴─────┴─────┴─────┘
****************************************
.SUBCKT AO21_DL A B C Y VDD VSS
*.PININFO A:I B:I C:I Y:O VDD:B VSS:B
MN0 n0 A VSS VSS sg13_lv_nmos w=2e-07 l=1.3e-07
MN1 n1 B n0 VSS sg13_lv_nmos w=2e-07 l=1.3e-07
MN2 n1 C VSS VSS sg13_lv_nmos w=1.5e-07 l=1.3e-07
MP0 n2 A VDD VDD sg13_lv_pmos w=3e-07 l=1.3e-07
MP1 n2 B VDD VDD sg13_lv_pmos w=3e-07 l=1.3e-07
MP2 n1 C n2 VDD sg13_lv_pmos w=3e-07 l=1.3e-07
MN3 Y n1 VSS VSS sg13_lv_nmos w=3.2e-07 l=1.3e-07 ng=1
MP3 Y n1 VDD VDD sg13_lv_pmos w=6.6e-07 l=1.3e-07 ng=1
.ENDS

****************************************
* Cell : AO22_D1
* Description : AND-OR gate with two two-input AND gates
* Reduced truth table for output Y
* ┌─────┬─────┬─────┬─────┬─────┐
* │ A   │ B   │ C   │ D   │   Y │
* ├─────┼─────┼─────┼─────┼─────┤
* │ 1   │ 1   │ -   │ -   │   1 │
* ├─────┼─────┼─────┼─────┼─────┤
* │ -   │ -   │ 1   │ 1   │   1 │
* ├─────┼─────┼─────┼─────┼─────┤
* │ 0   │ -   │ 0   │ -   │   0 │
* ├─────┼─────┼─────┼─────┼─────┤
* │ 0   │ -   │ -   │ 0   │   0 │
* ├─────┼─────┼─────┼─────┼─────┤
* │ -   │ 0   │ 0   │ -   │   0 │
* ├─────┼─────┼─────┼─────┼─────┤
* │ -   │ 0   │ -   │ 0   │   0 │
* └─────┴─────┴─────┴─────┴─────┘
****************************************
.SUBCKT AO22_D1 A B C D Y VDD VSS
*.PININFO A:I B:I C:I D:I Y:O VDD:B VSS:B
MN0 n0 A VSS VSS sg13_lv_nmos w=3e-07 l=1.3e-07
MN1 n1 B n0 VSS sg13_lv_nmos w=3e-07 l=1.3e-07
MN2 n2 C VSS VSS sg13_lv_nmos w=3e-07 l=1.3e-07
MN3 n1 D n2 VSS sg13_lv_nmos w=3e-07 l=1.3e-07
MP0 n3 A VDD VDD sg13_lv_pmos w=4e-07 l=1.3e-07
MP1 n3 B VDD VDD sg13_lv_pmos w=4e-07 l=1.3e-07
MP2 n1 C n3 VDD sg13_lv_pmos w=4e-07 l=1.3e-07
MP3 n1 D n3 VDD sg13_lv_pmos w=4e-07 l=1.3e-07
MN4 Y n1 VSS VSS sg13_lv_nmos w=6.4e-07 l=1.3e-07 ng=1
MP4 Y n1 VDD VDD sg13_lv_pmos w=9.8e-07 l=1.3e-07 ng=1
.ENDS

****************************************
* Cell : AO22_D2
* Description : AND-OR gate with two two-input AND gates
* Reduced truth table for output Y
* ┌─────┬─────┬─────┬─────┬─────┐
* │ A   │ B   │ C   │ D   │   Y │
* ├─────┼─────┼─────┼─────┼─────┤
* │ 1   │ 1   │ -   │ -   │   1 │
* ├─────┼─────┼─────┼─────┼─────┤
* │ -   │ -   │ 1   │ 1   │   1 │
* ├─────┼─────┼─────┼─────┼─────┤
* │ 0   │ -   │ 0   │ -   │   0 │
* ├─────┼─────┼─────┼─────┼─────┤
* │ 0   │ -   │ -   │ 0   │   0 │
* ├─────┼─────┼─────┼─────┼─────┤
* │ -   │ 0   │ 0   │ -   │   0 │
* ├─────┼─────┼─────┼─────┼─────┤
* │ -   │ 0   │ -   │ 0   │   0 │
* └─────┴─────┴─────┴─────┴─────┘
****************************************
.SUBCKT AO22_D2 A B C D Y VDD VSS
*.PININFO A:I B:I C:I D:I Y:O VDD:B VSS:B
MN0 n0 A VSS VSS sg13_lv_nmos w=5e-07 l=1.3e-07
MN1 n1 B n0 VSS sg13_lv_nmos w=5e-07 l=1.3e-07
MN2 n2 C VSS VSS sg13_lv_nmos w=5e-07 l=1.3e-07
MN3 n1 D n2 VSS sg13_lv_nmos w=5e-07 l=1.3e-07
MP0 n3 A VDD VDD sg13_lv_pmos w=6e-07 l=1.3e-07
MP1 n3 B VDD VDD sg13_lv_pmos w=6e-07 l=1.3e-07
MP2 n1 C n3 VDD sg13_lv_pmos w=6e-07 l=1.3e-07
MP3 n1 D n3 VDD sg13_lv_pmos w=6e-07 l=1.3e-07
MN4 Y n1 VSS VSS sg13_lv_nmos w=1.07e-06 l=1.3e-07 ng=1
MP4 Y n1 VDD VDD sg13_lv_pmos w=1.6e-06 l=1.3e-07 ng=1
.ENDS

****************************************
* Cell : AO22_DL
* Description : AND-OR gate with two two-input AND gates
* Reduced truth table for output Y
* ┌─────┬─────┬─────┬─────┬─────┐
* │ A   │ B   │ C   │ D   │   Y │
* ├─────┼─────┼─────┼─────┼─────┤
* │ 1   │ 1   │ -   │ -   │   1 │
* ├─────┼─────┼─────┼─────┼─────┤
* │ -   │ -   │ 1   │ 1   │   1 │
* ├─────┼─────┼─────┼─────┼─────┤
* │ 0   │ -   │ 0   │ -   │   0 │
* ├─────┼─────┼─────┼─────┼─────┤
* │ 0   │ -   │ -   │ 0   │   0 │
* ├─────┼─────┼─────┼─────┼─────┤
* │ -   │ 0   │ 0   │ -   │   0 │
* ├─────┼─────┼─────┼─────┼─────┤
* │ -   │ 0   │ -   │ 0   │   0 │
* └─────┴─────┴─────┴─────┴─────┘
****************************************
.SUBCKT AO22_DL A B C D Y VDD VSS
*.PININFO A:I B:I C:I D:I Y:O VDD:B VSS:B
MN0 n0 A VSS VSS sg13_lv_nmos w=2e-07 l=1.3e-07
MN1 n1 B n0 VSS sg13_lv_nmos w=2e-07 l=1.3e-07
MN2 n2 C VSS VSS sg13_lv_nmos w=2e-07 l=1.3e-07
MN3 n1 D n2 VSS sg13_lv_nmos w=2e-07 l=1.3e-07
MP0 n3 A VDD VDD sg13_lv_pmos w=3e-07 l=1.3e-07
MP1 n3 B VDD VDD sg13_lv_pmos w=3e-07 l=1.3e-07
MP2 n1 C n3 VDD sg13_lv_pmos w=3e-07 l=1.3e-07
MP3 n1 D n3 VDD sg13_lv_pmos w=3e-07 l=1.3e-07
MN4 Y n1 VSS VSS sg13_lv_nmos w=3.2e-07 l=1.3e-07 ng=1
MP4 Y n1 VDD VDD sg13_lv_pmos w=4.9e-07 l=1.3e-07 ng=1
.ENDS

****************************************
* Cell : AOI211_D1
* Description : Inverted output AND-OR gate with two input AND gate and two direct inputs to OR gate
* Reduced truth table for output Y
* ┌─────┬─────┬─────┬─────┬─────┐
* │ A   │ B   │ C   │ D   │   Y │
* ├─────┼─────┼─────┼─────┼─────┤
* │ 0   │ -   │ 0   │ 0   │   1 │
* ├─────┼─────┼─────┼─────┼─────┤
* │ -   │ 0   │ 0   │ 0   │   1 │
* ├─────┼─────┼─────┼─────┼─────┤
* │ -   │ -   │ 1   │ -   │   0 │
* ├─────┼─────┼─────┼─────┼─────┤
* │ -   │ -   │ -   │ 1   │   0 │
* ├─────┼─────┼─────┼─────┼─────┤
* │ 1   │ 1   │ -   │ -   │   0 │
* └─────┴─────┴─────┴─────┴─────┘
****************************************
.SUBCKT AOI211_D1 A B C D Y VDD VSS
*.PININFO A:I B:I C:I D:I Y:O VDD:B VSS:B
MN0 Y D VSS VSS sg13_lv_nmos w=6.4e-07 l=1.3e-07
MN1 Y C VSS VSS sg13_lv_nmos w=6.4e-07 l=1.3e-07
MN2 n0 B VSS VSS sg13_lv_nmos w=9e-07 l=1.3e-07
MN3 Y A n0 VSS sg13_lv_nmos w=9e-07 l=1.3e-07
MP0 n1 A VDD VDD sg13_lv_pmos w=1.28e-06 l=1.3e-07
MP1 n1 B VDD VDD sg13_lv_pmos w=1.28e-06 l=1.3e-07
MP2 n2 C n1 VDD sg13_lv_pmos w=1.28e-06 l=1.3e-07
MP3 Y D n2 VDD sg13_lv_pmos w=1.28e-06 l=1.3e-07
.ENDS

****************************************
* Cell : AOI211_D2
* Description : Inverted output AND-OR gate with two input AND gate and two direct inputs to OR gate
* Reduced truth table for output Y
* ┌─────┬─────┬─────┬─────┬─────┐
* │ A   │ B   │ C   │ D   │   Y │
* ├─────┼─────┼─────┼─────┼─────┤
* │ 0   │ -   │ 0   │ 0   │   1 │
* ├─────┼─────┼─────┼─────┼─────┤
* │ -   │ 0   │ 0   │ 0   │   1 │
* ├─────┼─────┼─────┼─────┼─────┤
* │ -   │ -   │ 1   │ -   │   0 │
* ├─────┼─────┼─────┼─────┼─────┤
* │ -   │ -   │ -   │ 1   │   0 │
* ├─────┼─────┼─────┼─────┼─────┤
* │ 1   │ 1   │ -   │ -   │   0 │
* └─────┴─────┴─────┴─────┴─────┘
****************************************
.SUBCKT AOI211_D2 A B C D Y VDD VSS
*.PININFO A:I B:I C:I D:I Y:O VDD:B VSS:B
MN0 Y D VSS VSS sg13_lv_nmos w=6.4e-07 l=1.3e-07
MN1 Y D VSS VSS sg13_lv_nmos w=6.4e-07 l=1.3e-07
MN2 Y C VSS VSS sg13_lv_nmos w=6.4e-07 l=1.3e-07
MN3 Y C VSS VSS sg13_lv_nmos w=6.4e-07 l=1.3e-07
MN4 n0 B VSS VSS sg13_lv_nmos w=9e-07 l=1.3e-07
MN5 n1 B VSS VSS sg13_lv_nmos w=9e-07 l=1.3e-07
MN6 Y A n0 VSS sg13_lv_nmos w=9e-07 l=1.3e-07
MN7 Y A n1 VSS sg13_lv_nmos w=9e-07 l=1.3e-07
MP0 n2 A VDD VDD sg13_lv_pmos w=2.56e-06 l=1.3e-07 ng=2
MP1 n2 B VDD VDD sg13_lv_pmos w=2.56e-06 l=1.3e-07 ng=2
MP2 n3 C n2 VDD sg13_lv_pmos w=1.28e-06 l=1.3e-07
MP3 n4 C n2 VDD sg13_lv_pmos w=1.28e-06 l=1.3e-07
MP4 Y D n3 VDD sg13_lv_pmos w=1.28e-06 l=1.3e-07
MP5 Y D n4 VDD sg13_lv_pmos w=1.28e-06 l=1.3e-07
.ENDS

****************************************
* Cell : AOI211_DL
* Description : Inverted output AND-OR gate with two input AND gate and two direct inputs to OR gate
* Reduced truth table for output Y
* ┌─────┬─────┬─────┬─────┬─────┐
* │ A   │ B   │ C   │ D   │   Y │
* ├─────┼─────┼─────┼─────┼─────┤
* │ 0   │ -   │ 0   │ 0   │   1 │
* ├─────┼─────┼─────┼─────┼─────┤
* │ -   │ 0   │ 0   │ 0   │   1 │
* ├─────┼─────┼─────┼─────┼─────┤
* │ -   │ -   │ 1   │ -   │   0 │
* ├─────┼─────┼─────┼─────┼─────┤
* │ -   │ -   │ -   │ 1   │   0 │
* ├─────┼─────┼─────┼─────┼─────┤
* │ 1   │ 1   │ -   │ -   │   0 │
* └─────┴─────┴─────┴─────┴─────┘
****************************************
.SUBCKT AOI211_DL A B C D Y VDD VSS
*.PININFO A:I B:I C:I D:I Y:O VDD:B VSS:B
MN0 Y D VSS VSS sg13_lv_nmos w=3e-07 l=1.3e-07
MN1 Y C VSS VSS sg13_lv_nmos w=3e-07 l=1.3e-07
MN2 n0 B VSS VSS sg13_lv_nmos w=4.5e-07 l=1.3e-07
MN3 Y A n0 VSS sg13_lv_nmos w=4.5e-07 l=1.3e-07
MP0 n1 A VDD VDD sg13_lv_pmos w=7.5e-07 l=1.3e-07
MP1 n1 B VDD VDD sg13_lv_pmos w=7.5e-07 l=1.3e-07
MP2 n2 C n1 VDD sg13_lv_pmos w=7.5e-07 l=1.3e-07
MP3 Y D n2 VDD sg13_lv_pmos w=7.5e-07 l=1.3e-07
.ENDS

****************************************
* Cell : AOI21_D1
* Description : Inverted output AND-OR gate with two AND inputs and one direct OR input
* Reduced truth table for output Y
* ┌─────┬─────┬─────┬─────┐
* │ A   │ B   │ C   │   Y │
* ├─────┼─────┼─────┼─────┤
* │ 0   │ -   │ 0   │   1 │
* ├─────┼─────┼─────┼─────┤
* │ -   │ 0   │ 0   │   1 │
* ├─────┼─────┼─────┼─────┤
* │ -   │ -   │ 1   │   0 │
* ├─────┼─────┼─────┼─────┤
* │ 1   │ 1   │ -   │   0 │
* └─────┴─────┴─────┴─────┘
****************************************
.SUBCKT AOI21_D1 A B C Y VDD VSS
*.PININFO A:I B:I C:I Y:O VDD:B VSS:B
MN0 n0 A VSS VSS sg13_lv_nmos w=9e-07 l=1.3e-07
MN1 Y B n0 VSS sg13_lv_nmos w=9e-07 l=1.3e-07
MN2 Y C VSS VSS sg13_lv_nmos w=6.4e-07 l=1.3e-07
MP0 n1 A VDD VDD sg13_lv_pmos w=1.28e-06 l=1.3e-07
MP1 n1 B VDD VDD sg13_lv_pmos w=1.28e-06 l=1.3e-07
MP2 Y C n1 VDD sg13_lv_pmos w=1.28e-06 l=1.3e-07
.ENDS

****************************************
* Cell : AOI21_D2
* Description : Inverted output AND-OR gate with two AND inputs and one direct OR input
* Reduced truth table for output Y
* ┌─────┬─────┬─────┬─────┐
* │ A   │ B   │ C   │   Y │
* ├─────┼─────┼─────┼─────┤
* │ 0   │ -   │ 0   │   1 │
* ├─────┼─────┼─────┼─────┤
* │ -   │ 0   │ 0   │   1 │
* ├─────┼─────┼─────┼─────┤
* │ -   │ -   │ 1   │   0 │
* ├─────┼─────┼─────┼─────┤
* │ 1   │ 1   │ -   │   0 │
* └─────┴─────┴─────┴─────┘
****************************************
.SUBCKT AOI21_D2 A B C Y VDD VSS
*.PININFO A:I B:I C:I Y:O VDD:B VSS:B
MN0 n0 A VSS VSS sg13_lv_nmos w=1.8e-06 l=1.3e-07 ng=2
MN1 Y B n0 VSS sg13_lv_nmos w=1.8e-06 l=1.3e-07 ng=2
MN2 Y C VSS VSS sg13_lv_nmos w=1.28e-06 l=1.3e-07 ng=2
MP0 n1 A VDD VDD sg13_lv_pmos w=1.28e-06 l=1.3e-07
MP1 n2 A VDD VDD sg13_lv_pmos w=1.28e-06 l=1.3e-07
MP2 n1 B VDD VDD sg13_lv_pmos w=1.28e-06 l=1.3e-07
MP3 n2 B VDD VDD sg13_lv_pmos w=1.28e-06 l=1.3e-07
MP4 Y C n1 VDD sg13_lv_pmos w=1.28e-06 l=1.3e-07
MP5 Y C n2 VDD sg13_lv_pmos w=1.28e-06 l=1.3e-07
.ENDS

****************************************
* Cell : AOI21_DL
* Description : Inverted output AND-OR gate with two AND inputs and one direct OR input
* Reduced truth table for output Y
* ┌─────┬─────┬─────┬─────┐
* │ A   │ B   │ C   │   Y │
* ├─────┼─────┼─────┼─────┤
* │ 0   │ -   │ 0   │   1 │
* ├─────┼─────┼─────┼─────┤
* │ -   │ 0   │ 0   │   1 │
* ├─────┼─────┼─────┼─────┤
* │ -   │ -   │ 1   │   0 │
* ├─────┼─────┼─────┼─────┤
* │ 1   │ 1   │ -   │   0 │
* └─────┴─────┴─────┴─────┘
****************************************
.SUBCKT AOI21_DL A B C Y VDD VSS
*.PININFO A:I B:I C:I Y:O VDD:B VSS:B
MN0 n0 A VSS VSS sg13_lv_nmos w=6e-07 l=1.3e-07
MN1 Y B n0 VSS sg13_lv_nmos w=6e-07 l=1.3e-07
MN2 Y C VSS VSS sg13_lv_nmos w=3e-07 l=1.3e-07
MP0 n1 A VDD VDD sg13_lv_pmos w=9e-07 l=1.3e-07
MP1 n1 B VDD VDD sg13_lv_pmos w=9e-07 l=1.3e-07
MP2 Y C n1 VDD sg13_lv_pmos w=9e-07 l=1.3e-07
.ENDS

****************************************
* Cell : AOI221_D1
* Description : Inverted output AND-OR gate with two two-input AND gates and one direct input to OR gate
* Reduced truth table for output Y
* ┌─────┬─────┬─────┬─────┬─────┬─────┐
* │ A   │ B   │ C   │ D   │ E   │   Y │
* ├─────┼─────┼─────┼─────┼─────┼─────┤
* │ 0   │ -   │ 0   │ -   │ 0   │   1 │
* ├─────┼─────┼─────┼─────┼─────┼─────┤
* │ 0   │ -   │ -   │ 0   │ 0   │   1 │
* ├─────┼─────┼─────┼─────┼─────┼─────┤
* │ -   │ 0   │ 0   │ -   │ 0   │   1 │
* ├─────┼─────┼─────┼─────┼─────┼─────┤
* │ -   │ 0   │ -   │ 0   │ 0   │   1 │
* ├─────┼─────┼─────┼─────┼─────┼─────┤
* │ -   │ -   │ -   │ -   │ 1   │   0 │
* ├─────┼─────┼─────┼─────┼─────┼─────┤
* │ 1   │ 1   │ -   │ -   │ -   │   0 │
* ├─────┼─────┼─────┼─────┼─────┼─────┤
* │ -   │ -   │ 1   │ 1   │ -   │   0 │
* └─────┴─────┴─────┴─────┴─────┴─────┘
****************************************
.SUBCKT AOI221_D1 A B C D E Y VDD VSS
*.PININFO A:I B:I C:I D:I E:I Y:O VDD:B VSS:B
MN0 n0 D VSS VSS sg13_lv_nmos w=9e-07 l=1.3e-07
MN1 Y C n0 VSS sg13_lv_nmos w=9e-07 l=1.3e-07
MN2 n1 B VSS VSS sg13_lv_nmos w=9e-07 l=1.3e-07
MN3 Y A n1 VSS sg13_lv_nmos w=9e-07 l=1.3e-07
MN4 Y E VSS VSS sg13_lv_nmos w=6.4e-07 l=1.3e-07
MP0 n2 A VDD VDD sg13_lv_pmos w=1.6e-06 l=1.3e-07
MP1 n2 B VDD VDD sg13_lv_pmos w=1.6e-06 l=1.3e-07
MP2 n3 C n2 VDD sg13_lv_pmos w=1.6e-06 l=1.3e-07
MP3 n3 D n2 VDD sg13_lv_pmos w=1.6e-06 l=1.3e-07
MP4 Y E n3 VDD sg13_lv_pmos w=1.6e-06 l=1.3e-07
.ENDS

****************************************
* Cell : AOI221_DL
* Description : Inverted output AND-OR gate with two two-input AND gates and one direct input to OR gate
* Reduced truth table for output Y
* ┌─────┬─────┬─────┬─────┬─────┬─────┐
* │ A   │ B   │ C   │ D   │ E   │   Y │
* ├─────┼─────┼─────┼─────┼─────┼─────┤
* │ 0   │ -   │ 0   │ -   │ 0   │   1 │
* ├─────┼─────┼─────┼─────┼─────┼─────┤
* │ 0   │ -   │ -   │ 0   │ 0   │   1 │
* ├─────┼─────┼─────┼─────┼─────┼─────┤
* │ -   │ 0   │ 0   │ -   │ 0   │   1 │
* ├─────┼─────┼─────┼─────┼─────┼─────┤
* │ -   │ 0   │ -   │ 0   │ 0   │   1 │
* ├─────┼─────┼─────┼─────┼─────┼─────┤
* │ -   │ -   │ -   │ -   │ 1   │   0 │
* ├─────┼─────┼─────┼─────┼─────┼─────┤
* │ 1   │ 1   │ -   │ -   │ -   │   0 │
* ├─────┼─────┼─────┼─────┼─────┼─────┤
* │ -   │ -   │ 1   │ 1   │ -   │   0 │
* └─────┴─────┴─────┴─────┴─────┴─────┘
****************************************
.SUBCKT AOI221_DL A B C D E Y VDD VSS
*.PININFO A:I B:I C:I D:I E:I Y:O VDD:B VSS:B
MN0 n0 D VSS VSS sg13_lv_nmos w=6.25e-07 l=1.3e-07
MN1 Y C n0 VSS sg13_lv_nmos w=6.25e-07 l=1.3e-07
MN2 n1 B VSS VSS sg13_lv_nmos w=6.25e-07 l=1.3e-07
MN3 Y A n1 VSS sg13_lv_nmos w=6.25e-07 l=1.3e-07
MN4 Y E VSS VSS sg13_lv_nmos w=4.1e-07 l=1.3e-07
MP0 n2 A VDD VDD sg13_lv_pmos w=8.7e-07 l=1.3e-07
MP1 n2 B VDD VDD sg13_lv_pmos w=8.7e-07 l=1.3e-07
MP2 n3 C n2 VDD sg13_lv_pmos w=8.7e-07 l=1.3e-07
MP3 n3 D n2 VDD sg13_lv_pmos w=8.7e-07 l=1.3e-07
MP4 Y E n3 VDD sg13_lv_pmos w=8.7e-07 l=1.3e-07
.ENDS

****************************************
* Cell : AOI222_D1
* Description : Inverted output AND-OR gate with three two-input AND gates
* Reduced truth table for output Y
* ┌─────┬─────┬─────┬─────┬─────┬─────┬─────┐
* │ A   │ B   │ C   │ D   │ E   │ F   │   Y │
* ├─────┼─────┼─────┼─────┼─────┼─────┼─────┤
* │ 0   │ -   │ 0   │ -   │ 0   │ -   │   1 │
* ├─────┼─────┼─────┼─────┼─────┼─────┼─────┤
* │ 0   │ -   │ 0   │ -   │ -   │ 0   │   1 │
* ├─────┼─────┼─────┼─────┼─────┼─────┼─────┤
* │ 0   │ -   │ -   │ 0   │ 0   │ -   │   1 │
* ├─────┼─────┼─────┼─────┼─────┼─────┼─────┤
* │ 0   │ -   │ -   │ 0   │ -   │ 0   │   1 │
* ├─────┼─────┼─────┼─────┼─────┼─────┼─────┤
* │ -   │ 0   │ 0   │ -   │ 0   │ -   │   1 │
* ├─────┼─────┼─────┼─────┼─────┼─────┼─────┤
* │ -   │ 0   │ 0   │ -   │ -   │ 0   │   1 │
* ├─────┼─────┼─────┼─────┼─────┼─────┼─────┤
* │ -   │ 0   │ -   │ 0   │ 0   │ -   │   1 │
* ├─────┼─────┼─────┼─────┼─────┼─────┼─────┤
* │ -   │ 0   │ -   │ 0   │ -   │ 0   │   1 │
* ├─────┼─────┼─────┼─────┼─────┼─────┼─────┤
* │ 1   │ 1   │ -   │ -   │ -   │ -   │   0 │
* ├─────┼─────┼─────┼─────┼─────┼─────┼─────┤
* │ -   │ -   │ 1   │ 1   │ -   │ -   │   0 │
* ├─────┼─────┼─────┼─────┼─────┼─────┼─────┤
* │ -   │ -   │ -   │ -   │ 1   │ 1   │   0 │
* └─────┴─────┴─────┴─────┴─────┴─────┴─────┘
****************************************
.SUBCKT AOI222_D1 A B C D E F Y VDD VSS
*.PININFO A:I B:I C:I D:I E:I F:I Y:O VDD:B VSS:B
MN0 n0 D VSS VSS sg13_lv_nmos w=9e-07 l=1.3e-07
MN1 Y C n0 VSS sg13_lv_nmos w=9e-07 l=1.3e-07
MN2 n1 B VSS VSS sg13_lv_nmos w=9e-07 l=1.3e-07
MN3 Y A n1 VSS sg13_lv_nmos w=9e-07 l=1.3e-07
MN4 Y E n2 VSS sg13_lv_nmos w=9e-07 l=1.3e-07
MN5 n2 F VSS VSS sg13_lv_nmos w=9e-07 l=1.3e-07
MP0 n3 A VDD VDD sg13_lv_pmos w=1.6e-06 l=1.3e-07
MP1 n3 B VDD VDD sg13_lv_pmos w=1.6e-06 l=1.3e-07
MP2 n4 C n3 VDD sg13_lv_pmos w=1.6e-06 l=1.3e-07
MP3 n4 D n3 VDD sg13_lv_pmos w=1.6e-06 l=1.3e-07
MP4 Y E n4 VDD sg13_lv_pmos w=1.6e-06 l=1.3e-07
MP5 Y F n4 VDD sg13_lv_pmos w=1.6e-06 l=1.3e-07
.ENDS

****************************************
* Cell : AOI222_DL
* Description : Inverted output AND-OR gate with three two-input AND gates
* Reduced truth table for output Y
* ┌─────┬─────┬─────┬─────┬─────┬─────┬─────┐
* │ A   │ B   │ C   │ D   │ E   │ F   │   Y │
* ├─────┼─────┼─────┼─────┼─────┼─────┼─────┤
* │ 0   │ -   │ 0   │ -   │ 0   │ -   │   1 │
* ├─────┼─────┼─────┼─────┼─────┼─────┼─────┤
* │ 0   │ -   │ 0   │ -   │ -   │ 0   │   1 │
* ├─────┼─────┼─────┼─────┼─────┼─────┼─────┤
* │ 0   │ -   │ -   │ 0   │ 0   │ -   │   1 │
* ├─────┼─────┼─────┼─────┼─────┼─────┼─────┤
* │ 0   │ -   │ -   │ 0   │ -   │ 0   │   1 │
* ├─────┼─────┼─────┼─────┼─────┼─────┼─────┤
* │ -   │ 0   │ 0   │ -   │ 0   │ -   │   1 │
* ├─────┼─────┼─────┼─────┼─────┼─────┼─────┤
* │ -   │ 0   │ 0   │ -   │ -   │ 0   │   1 │
* ├─────┼─────┼─────┼─────┼─────┼─────┼─────┤
* │ -   │ 0   │ -   │ 0   │ 0   │ -   │   1 │
* ├─────┼─────┼─────┼─────┼─────┼─────┼─────┤
* │ -   │ 0   │ -   │ 0   │ -   │ 0   │   1 │
* ├─────┼─────┼─────┼─────┼─────┼─────┼─────┤
* │ 1   │ 1   │ -   │ -   │ -   │ -   │   0 │
* ├─────┼─────┼─────┼─────┼─────┼─────┼─────┤
* │ -   │ -   │ 1   │ 1   │ -   │ -   │   0 │
* ├─────┼─────┼─────┼─────┼─────┼─────┼─────┤
* │ -   │ -   │ -   │ -   │ 1   │ 1   │   0 │
* └─────┴─────┴─────┴─────┴─────┴─────┴─────┘
****************************************
.SUBCKT AOI222_DL A B C D E F Y VDD VSS
*.PININFO A:I B:I C:I D:I E:I F:I Y:O VDD:B VSS:B
MN0 n0 D VSS VSS sg13_lv_nmos w=5e-07 l=1.3e-07
MN1 Y C n0 VSS sg13_lv_nmos w=5e-07 l=1.3e-07
MN2 n1 B VSS VSS sg13_lv_nmos w=5e-07 l=1.3e-07
MN3 Y A n1 VSS sg13_lv_nmos w=5e-07 l=1.3e-07
MN4 Y E n2 VSS sg13_lv_nmos w=5e-07 l=1.3e-07
MN5 n2 F VSS VSS sg13_lv_nmos w=5e-07 l=1.3e-07
MP0 n3 A VDD VDD sg13_lv_pmos w=1e-06 l=1.3e-07
MP1 n3 B VDD VDD sg13_lv_pmos w=1e-06 l=1.3e-07
MP2 n4 C n3 VDD sg13_lv_pmos w=1e-06 l=1.3e-07
MP3 n4 D n3 VDD sg13_lv_pmos w=1e-06 l=1.3e-07
MP4 Y E n4 VDD sg13_lv_pmos w=1e-06 l=1.3e-07
MP5 Y F n4 VDD sg13_lv_pmos w=1e-06 l=1.3e-07
.ENDS

****************************************
* Cell : AOI22_D1
* Description : Inverted output AND-OR gate with two two-input AND gates
* Reduced truth table for output Y
* ┌─────┬─────┬─────┬─────┬─────┐
* │ A   │ B   │ C   │ D   │   Y │
* ├─────┼─────┼─────┼─────┼─────┤
* │ 0   │ -   │ 0   │ -   │   1 │
* ├─────┼─────┼─────┼─────┼─────┤
* │ 0   │ -   │ -   │ 0   │   1 │
* ├─────┼─────┼─────┼─────┼─────┤
* │ -   │ 0   │ 0   │ -   │   1 │
* ├─────┼─────┼─────┼─────┼─────┤
* │ -   │ 0   │ -   │ 0   │   1 │
* ├─────┼─────┼─────┼─────┼─────┤
* │ 1   │ 1   │ -   │ -   │   0 │
* ├─────┼─────┼─────┼─────┼─────┤
* │ -   │ -   │ 1   │ 1   │   0 │
* └─────┴─────┴─────┴─────┴─────┘
****************************************
.SUBCKT AOI22_D1 A B C D Y VDD VSS
*.PININFO A:I B:I C:I D:I Y:O VDD:B VSS:B
MN0 n0 D VSS VSS sg13_lv_nmos w=9e-07 l=1.3e-07
MN1 Y C n0 VSS sg13_lv_nmos w=9e-07 l=1.3e-07
MN2 n1 B VSS VSS sg13_lv_nmos w=9e-07 l=1.3e-07
MN3 Y A n1 VSS sg13_lv_nmos w=9e-07 l=1.3e-07
MP0 n2 A VDD VDD sg13_lv_pmos w=1.28e-06 l=1.3e-07
MP1 n2 B VDD VDD sg13_lv_pmos w=1.28e-06 l=1.3e-07
MP2 Y C n2 VDD sg13_lv_pmos w=1.28e-06 l=1.3e-07
MP3 Y D n2 VDD sg13_lv_pmos w=1.28e-06 l=1.3e-07
.ENDS

****************************************
* Cell : AOI22_DL
* Description : Inverted output AND-OR gate with two two-input AND gates
* Reduced truth table for output Y
* ┌─────┬─────┬─────┬─────┬─────┐
* │ A   │ B   │ C   │ D   │   Y │
* ├─────┼─────┼─────┼─────┼─────┤
* │ 0   │ -   │ 0   │ -   │   1 │
* ├─────┼─────┼─────┼─────┼─────┤
* │ 0   │ -   │ -   │ 0   │   1 │
* ├─────┼─────┼─────┼─────┼─────┤
* │ -   │ 0   │ 0   │ -   │   1 │
* ├─────┼─────┼─────┼─────┼─────┤
* │ -   │ 0   │ -   │ 0   │   1 │
* ├─────┼─────┼─────┼─────┼─────┤
* │ 1   │ 1   │ -   │ -   │   0 │
* ├─────┼─────┼─────┼─────┼─────┤
* │ -   │ -   │ 1   │ 1   │   0 │
* └─────┴─────┴─────┴─────┴─────┘
****************************************
.SUBCKT AOI22_DL A B C D Y VDD VSS
*.PININFO A:I B:I C:I D:I Y:O VDD:B VSS:B
MN0 n0 D VSS VSS sg13_lv_nmos w=5e-07 l=1.3e-07
MN1 Y C n0 VSS sg13_lv_nmos w=5e-07 l=1.3e-07
MN2 n1 B VSS VSS sg13_lv_nmos w=5e-07 l=1.3e-07
MN3 Y A n1 VSS sg13_lv_nmos w=5e-07 l=1.3e-07
MP0 n2 A VDD VDD sg13_lv_pmos w=7.5e-07 l=1.3e-07
MP1 n2 B VDD VDD sg13_lv_pmos w=7.5e-07 l=1.3e-07
MP2 Y C n2 VDD sg13_lv_pmos w=7.5e-07 l=1.3e-07
MP3 Y D n2 VDD sg13_lv_pmos w=7.5e-07 l=1.3e-07
.ENDS

****************************************
* Cell : AOI2N1_D1
* Description : Inverted output AND-OR gate with two inverted AND inputs and one direct OR input. Eqivalent to OR-AND gate with inverted direct OR input.
* Reduced truth table for output Y
* ┌─────┬─────┬─────┬─────┐
* │ A   │ B   │ C   │   Y │
* ├─────┼─────┼─────┼─────┤
* │ 1   │ -   │ 0   │   1 │
* ├─────┼─────┼─────┼─────┤
* │ -   │ 1   │ 0   │   1 │
* ├─────┼─────┼─────┼─────┤
* │ -   │ -   │ 1   │   0 │
* ├─────┼─────┼─────┼─────┤
* │ 0   │ 0   │ -   │   0 │
* └─────┴─────┴─────┴─────┘
****************************************
.SUBCKT AOI2N1_D1 A B C Y VDD VSS
*.PININFO A:I B:I C:I Y:O VDD:B VSS:B
MN0 n0 A VSS VSS sg13_lv_nmos w=2.5e-07 l=1.3e-07
MN1 n0 B VSS VSS sg13_lv_nmos w=2.5e-07 l=1.3e-07
MN2 Y n0 VSS VSS sg13_lv_nmos w=6.4e-07 l=1.3e-07
MN3 Y C VSS VSS sg13_lv_nmos w=6.4e-07 l=1.3e-07
MP0 n1 A VDD VDD sg13_lv_pmos w=5e-07 l=1.3e-07
MP1 n1 B n0 VDD sg13_lv_pmos w=5e-07 l=1.3e-07
MP2 Y C n2 VDD sg13_lv_pmos w=1.28e-06 l=1.3e-07
MP3 n2 n0 VDD VDD sg13_lv_pmos w=1.28e-06 l=1.3e-07
.ENDS

****************************************
* Cell : AOI2N1_D2
* Description : Inverted output AND-OR gate with two inverted AND inputs and one direct OR input. Eqivalent to OR-AND gate with inverted direct OR input.
* Reduced truth table for output Y
* ┌─────┬─────┬─────┬─────┐
* │ A   │ B   │ C   │   Y │
* ├─────┼─────┼─────┼─────┤
* │ 1   │ -   │ 0   │   1 │
* ├─────┼─────┼─────┼─────┤
* │ -   │ 1   │ 0   │   1 │
* ├─────┼─────┼─────┼─────┤
* │ -   │ -   │ 1   │   0 │
* ├─────┼─────┼─────┼─────┤
* │ 0   │ 0   │ -   │   0 │
* └─────┴─────┴─────┴─────┘
****************************************
.SUBCKT AOI2N1_D2 A B C Y VDD VSS
*.PININFO A:I B:I C:I Y:O VDD:B VSS:B
MN0 n0 A VSS VSS sg13_lv_nmos w=2.5e-07 l=1.3e-07
MN1 n0 B VSS VSS sg13_lv_nmos w=2.5e-07 l=1.3e-07
MN2 Y n0 VSS VSS sg13_lv_nmos w=6.4e-07 l=1.3e-07
MN3 Y C VSS VSS sg13_lv_nmos w=6.4e-07 l=1.3e-07
MP0 n1 A VDD VDD sg13_lv_pmos w=5e-07 l=1.3e-07
MP1 n1 B n0 VDD sg13_lv_pmos w=5e-07 l=1.3e-07
MP2 Y C n2 VDD sg13_lv_pmos w=1.28e-06 l=1.3e-07
MP3 n2 n0 VDD VDD sg13_lv_pmos w=1.28e-06 l=1.3e-07
MN4 n3 A VSS VSS sg13_lv_nmos w=2.5e-07 l=1.3e-07
MN5 n3 B VSS VSS sg13_lv_nmos w=2.5e-07 l=1.3e-07
MN6 Y n3 VSS VSS sg13_lv_nmos w=6.4e-07 l=1.3e-07
MN7 Y C VSS VSS sg13_lv_nmos w=6.4e-07 l=1.3e-07
MP4 n4 A VDD VDD sg13_lv_pmos w=5e-07 l=1.3e-07
MP5 n4 B n3 VDD sg13_lv_pmos w=5e-07 l=1.3e-07
MP6 Y C n5 VDD sg13_lv_pmos w=1.28e-06 l=1.3e-07
MP7 n5 n3 VDD VDD sg13_lv_pmos w=1.28e-06 l=1.3e-07
.ENDS

****************************************
* Cell : AOI2N1_DL
* Description : Inverted output AND-OR gate with two inverted AND inputs and one direct OR input. Eqivalent to OR-AND gate with inverted direct OR input.
* Reduced truth table for output Y
* ┌─────┬─────┬─────┬─────┐
* │ A   │ B   │ C   │   Y │
* ├─────┼─────┼─────┼─────┤
* │ 1   │ -   │ 0   │   1 │
* ├─────┼─────┼─────┼─────┤
* │ -   │ 1   │ 0   │   1 │
* ├─────┼─────┼─────┼─────┤
* │ -   │ -   │ 1   │   0 │
* ├─────┼─────┼─────┼─────┤
* │ 0   │ 0   │ -   │   0 │
* └─────┴─────┴─────┴─────┘
****************************************
.SUBCKT AOI2N1_DL A B C Y VDD VSS
*.PININFO A:I B:I C:I Y:O VDD:B VSS:B
MN0 n0 A VSS VSS sg13_lv_nmos w=1.5e-07 l=1.3e-07
MN1 n0 B VSS VSS sg13_lv_nmos w=1.5e-07 l=1.3e-07
MN2 Y n0 VSS VSS sg13_lv_nmos w=3.2e-07 l=1.3e-07
MN3 Y C VSS VSS sg13_lv_nmos w=3.2e-07 l=1.3e-07
MP0 n1 A VDD VDD sg13_lv_pmos w=3e-07 l=1.3e-07
MP1 n1 B n0 VDD sg13_lv_pmos w=3e-07 l=1.3e-07
MP2 Y C n2 VDD sg13_lv_pmos w=6.4e-07 l=1.3e-07
MP3 n2 n0 VDD VDD sg13_lv_pmos w=6.4e-07 l=1.3e-07
.ENDS

****************************************
* Cell : AOI2N2_D1
* Description : Inverted output AND-OR gate with two two-input AND gates. One AND gate has inverted inputs.
* Reduced truth table for output Y
* ┌─────┬─────┬─────┬─────┬─────┐
* │ A   │ B   │ C   │ D   │   Y │
* ├─────┼─────┼─────┼─────┼─────┤
* │ 1   │ -   │ 0   │ -   │   1 │
* ├─────┼─────┼─────┼─────┼─────┤
* │ 1   │ -   │ -   │ 0   │   1 │
* ├─────┼─────┼─────┼─────┼─────┤
* │ -   │ 1   │ 0   │ -   │   1 │
* ├─────┼─────┼─────┼─────┼─────┤
* │ -   │ 1   │ -   │ 0   │   1 │
* ├─────┼─────┼─────┼─────┼─────┤
* │ 0   │ 0   │ -   │ -   │   0 │
* ├─────┼─────┼─────┼─────┼─────┤
* │ -   │ -   │ 1   │ 1   │   0 │
* └─────┴─────┴─────┴─────┴─────┘
****************************************
.SUBCKT AOI2N2_D1 A B C D Y VDD VSS
*.PININFO A:I B:I C:I D:I Y:O VDD:B VSS:B
MN0 n0 A VSS VSS sg13_lv_nmos w=2.5e-07 l=1.3e-07
MN1 n0 B VSS VSS sg13_lv_nmos w=2.5e-07 l=1.3e-07
MN2 Y n0 VSS VSS sg13_lv_nmos w=6.4e-07 l=1.3e-07
MN3 Y D n1 VSS sg13_lv_nmos w=6.4e-07 l=1.3e-07
MN4 n1 C VSS VSS sg13_lv_nmos w=6.4e-07 l=1.3e-07
MP0 n2 A VDD VDD sg13_lv_pmos w=5e-07 l=1.3e-07
MP1 n0 B n2 VDD sg13_lv_pmos w=5e-07 l=1.3e-07
MP2 n3 n0 VDD VDD sg13_lv_pmos w=1.28e-06 l=1.3e-07
MP3 Y C n3 VDD sg13_lv_pmos w=1.28e-06 l=1.3e-07
MP4 Y D n3 VDD sg13_lv_pmos w=1.28e-06 l=1.3e-07
.ENDS

****************************************
* Cell : BUF_D1
* Description : Standard buffer
* Reduced truth table for output Y
* ┌─────┬─────┐
* │   A │   Y │
* ├─────┼─────┤
* │   1 │   1 │
* ├─────┼─────┤
* │   0 │   0 │
* └─────┴─────┘
****************************************
.SUBCKT BUF_D1 A Y VDD VSS
*.PININFO A:I Y:O VDD:B VSS:B
MN0 n0 A VSS VSS sg13_lv_nmos w=2e-07 l=1.3e-07 ng=1
MP0 n0 A VDD VDD sg13_lv_pmos w=3e-07 l=1.3e-07 ng=1
MN1 Y n0 VSS VSS sg13_lv_nmos w=6.4e-07 l=1.3e-07 ng=1
MP1 Y n0 VDD VDD sg13_lv_pmos w=9.8e-07 l=1.3e-07 ng=1
.ENDS

****************************************
* Cell : BUF_D12
* Description : Standard buffer
* Reduced truth table for output Y
* ┌─────┬─────┐
* │   A │   Y │
* ├─────┼─────┤
* │   1 │   1 │
* ├─────┼─────┤
* │   0 │   0 │
* └─────┴─────┘
****************************************
.SUBCKT BUF_D12 A Y VDD VSS
*.PININFO A:I Y:O VDD:B VSS:B
MN0 n0 A VSS VSS sg13_lv_nmos w=2.4e-06 l=1.3e-07 ng=3
MP0 n0 A VDD VDD sg13_lv_pmos w=3.6e-06 l=1.3e-07 ng=3
MN1 Y n0 VSS VSS sg13_lv_nmos w=6.425e-06 l=1.3e-07 ng=7
MP1 Y n0 VDD VDD sg13_lv_pmos w=9.6e-06 l=1.3e-07 ng=7
.ENDS

****************************************
* Cell : BUF_D2
* Description : Standard buffer
* Reduced truth table for output Y
* ┌─────┬─────┐
* │   A │   Y │
* ├─────┼─────┤
* │   1 │   1 │
* ├─────┼─────┤
* │   0 │   0 │
* └─────┴─────┘
****************************************
.SUBCKT BUF_D2 A Y VDD VSS
*.PININFO A:I Y:O VDD:B VSS:B
MN0 n0 A VSS VSS sg13_lv_nmos w=4e-07 l=1.3e-07 ng=1
MP0 n0 A VDD VDD sg13_lv_pmos w=6e-07 l=1.3e-07 ng=1
MN1 Y n0 VSS VSS sg13_lv_nmos w=1.07e-06 l=1.3e-07 ng=1
MP1 Y n0 VDD VDD sg13_lv_pmos w=1.6e-06 l=1.3e-07 ng=1
.ENDS

****************************************
* Cell : BUF_D3
* Description : Standard buffer
* Reduced truth table for output Y
* ┌─────┬─────┐
* │   A │   Y │
* ├─────┼─────┤
* │   1 │   1 │
* ├─────┼─────┤
* │   0 │   0 │
* └─────┴─────┘
****************************************
.SUBCKT BUF_D3 A Y VDD VSS
*.PININFO A:I Y:O VDD:B VSS:B
MN0 n0 A VSS VSS sg13_lv_nmos w=5.6e-07 l=1.3e-07 ng=1
MP0 n0 A VDD VDD sg13_lv_pmos w=8.4e-07 l=1.3e-07 ng=1
MN1 Y n0 VSS VSS sg13_lv_nmos w=1.5e-06 l=1.3e-07 ng=2
MP1 Y n0 VDD VDD sg13_lv_pmos w=2.2e-06 l=1.3e-07 ng=2
.ENDS

****************************************
* Cell : BUF_D4
* Description : Standard buffer
* Reduced truth table for output Y
* ┌─────┬─────┐
* │   A │   Y │
* ├─────┼─────┤
* │   1 │   1 │
* ├─────┼─────┤
* │   0 │   0 │
* └─────┴─────┘
****************************************
.SUBCKT BUF_D4 A Y VDD VSS
*.PININFO A:I Y:O VDD:B VSS:B
MN0 n0 A VSS VSS sg13_lv_nmos w=7.4e-07 l=1.3e-07 ng=1
MP0 n0 A VDD VDD sg13_lv_pmos w=1.2e-06 l=1.3e-07 ng=1
MN1 Y n0 VSS VSS sg13_lv_nmos w=2.14e-06 l=1.3e-07 ng=3
MP1 Y n0 VDD VDD sg13_lv_pmos w=3.2e-06 l=1.3e-07 ng=3
.ENDS

****************************************
* Cell : BUF_D6
* Description : Standard buffer
* Reduced truth table for output Y
* ┌─────┬─────┐
* │   A │   Y │
* ├─────┼─────┤
* │   1 │   1 │
* ├─────┼─────┤
* │   0 │   0 │
* └─────┴─────┘
****************************************
.SUBCKT BUF_D6 A Y VDD VSS
*.PININFO A:I Y:O VDD:B VSS:B
MN0 n0 A VSS VSS sg13_lv_nmos w=1e-06 l=1.3e-07 ng=1
MP0 n0 A VDD VDD sg13_lv_pmos w=1.5e-06 l=1.3e-07 ng=1
MN1 Y n0 VSS VSS sg13_lv_nmos w=2.6e-06 l=1.3e-07 ng=3
MP1 Y n0 VDD VDD sg13_lv_pmos w=4e-06 l=1.3e-07 ng=3
.ENDS

****************************************
* Cell : BUF_D8
* Description : Standard buffer
* Reduced truth table for output Y
* ┌─────┬─────┐
* │   A │   Y │
* ├─────┼─────┤
* │   1 │   1 │
* ├─────┼─────┤
* │   0 │   0 │
* └─────┴─────┘
****************************************
.SUBCKT BUF_D8 A Y VDD VSS
*.PININFO A:I Y:O VDD:B VSS:B
MN0 n0 A VSS VSS sg13_lv_nmos w=1.6e-06 l=1.3e-07 ng=2
MP0 n0 A VDD VDD sg13_lv_pmos w=2.4e-06 l=1.3e-07 ng=2
MN1 Y n0 VSS VSS sg13_lv_nmos w=4.28e-06 l=1.3e-07 ng=5
MP1 Y n0 VDD VDD sg13_lv_pmos w=6.4e-06 l=1.3e-07 ng=5
.ENDS

****************************************
* Cell : BUF_DL
* Description : Standard buffer
* Reduced truth table for output Y
* ┌─────┬─────┐
* │   A │   Y │
* ├─────┼─────┤
* │   1 │   1 │
* ├─────┼─────┤
* │   0 │   0 │
* └─────┴─────┘
****************************************
.SUBCKT BUF_DL A Y VDD VSS
*.PININFO A:I Y:O VDD:B VSS:B
MN0 n0 A VSS VSS sg13_lv_nmos w=1.5e-07 l=1.3e-07 ng=1
MP0 n0 A VDD VDD sg13_lv_pmos w=2e-07 l=1.3e-07 ng=1
MN1 Y n0 VSS VSS sg13_lv_nmos w=3.2e-07 l=1.3e-07 ng=1
MP1 Y n0 VDD VDD sg13_lv_pmos w=6.6e-07 l=1.3e-07 ng=1
.ENDS

****************************************
* Cell : CLKBUF_D1
* Description : Clock buffer for clock tree synthesis
* Reduced truth table for output Y
* ┌─────┬─────┐
* │   A │   Y │
* ├─────┼─────┤
* │   1 │   1 │
* ├─────┼─────┤
* │   0 │   0 │
* └─────┴─────┘
****************************************
.SUBCKT CLKBUF_D1 A Y VDD VSS
*.PININFO A:I Y:O VDD:B VSS:B
MN0 n0 A VSS VSS sg13_lv_nmos w=1.5e-07 l=1.3e-07 ng=1
MP0 n0 A VDD VDD sg13_lv_pmos w=4.3e-07 l=1.3e-07 ng=1
MN1 Y n0 VSS VSS sg13_lv_nmos w=3.4e-07 l=1.3e-07 ng=1
MP1 Y n0 VDD VDD sg13_lv_pmos w=9.8e-07 l=1.3e-07 ng=1
.ENDS

****************************************
* Cell : CLKBUF_D12
* Description : Clock buffer for clock tree synthesis
* Reduced truth table for output Y
* ┌─────┬─────┐
* │   A │   Y │
* ├─────┼─────┤
* │   1 │   1 │
* ├─────┼─────┤
* │   0 │   0 │
* └─────┴─────┘
****************************************
.SUBCKT CLKBUF_D12 A Y VDD VSS
*.PININFO A:I Y:O VDD:B VSS:B
MN0 n0 A VSS VSS sg13_lv_nmos w=1.1e-06 l=1.3e-07 ng=1
MP0 n0 A VDD VDD sg13_lv_pmos w=3.3e-06 l=1.3e-07 ng=1
MN1 Y n0 VSS VSS sg13_lv_nmos w=3.3e-06 l=1.3e-07 ng=6
MP1 Y n0 VDD VDD sg13_lv_pmos w=9.9e-06 l=1.3e-07 ng=6
.ENDS

****************************************
* Cell : CLKBUF_D16
* Description : Clock buffer for clock tree synthesis
* Reduced truth table for output Y
* ┌─────┬─────┐
* │   A │   Y │
* ├─────┼─────┤
* │   1 │   1 │
* ├─────┼─────┤
* │   0 │   0 │
* └─────┴─────┘
****************************************
.SUBCKT CLKBUF_D16 A Y VDD VSS
*.PININFO A:I Y:O VDD:B VSS:B
MN0 n0 A VSS VSS sg13_lv_nmos w=1.4e-06 l=1.3e-07 ng=1
MP0 n0 A VDD VDD sg13_lv_pmos w=4.2e-06 l=1.3e-07 ng=1
MN1 Y n0 VSS VSS sg13_lv_nmos w=4e-06 l=1.3e-07 ng=8
MP1 Y n0 VDD VDD sg13_lv_pmos w=1.2e-05 l=1.3e-07 ng=8
.ENDS

****************************************
* Cell : CLKBUF_D2
* Description : Clock buffer for clock tree synthesis
* Reduced truth table for output Y
* ┌─────┬─────┐
* │   A │   Y │
* ├─────┼─────┤
* │   1 │   1 │
* ├─────┼─────┤
* │   0 │   0 │
* └─────┴─────┘
****************************************
.SUBCKT CLKBUF_D2 A Y VDD VSS
*.PININFO A:I Y:O VDD:B VSS:B
MN0 n0 A VSS VSS sg13_lv_nmos w=2e-07 l=1.3e-07 ng=1
MP0 n0 A VDD VDD sg13_lv_pmos w=5.8e-07 l=1.3e-07 ng=1
MN1 Y n0 VSS VSS sg13_lv_nmos w=5e-07 l=1.3e-07 ng=1
MP1 Y n0 VDD VDD sg13_lv_pmos w=1.45e-06 l=1.3e-07 ng=1
.ENDS

****************************************
* Cell : CLKBUF_D3
* Description : Clock buffer for clock tree synthesis
* Reduced truth table for output Y
* ┌─────┬─────┐
* │   A │   Y │
* ├─────┼─────┤
* │   1 │   1 │
* ├─────┼─────┤
* │   0 │   0 │
* └─────┴─────┘
****************************************
.SUBCKT CLKBUF_D3 A Y VDD VSS
*.PININFO A:I Y:O VDD:B VSS:B
MN0 n0 A VSS VSS sg13_lv_nmos w=3e-07 l=1.3e-07 ng=1
MP0 n0 A VDD VDD sg13_lv_pmos w=8.7e-07 l=1.3e-07 ng=1
MN1 Y n0 VSS VSS sg13_lv_nmos w=8e-07 l=1.3e-07 ng=1
MP1 Y n0 VDD VDD sg13_lv_pmos w=2.2e-06 l=1.3e-07 ng=2
.ENDS

****************************************
* Cell : CLKBUF_D4
* Description : Clock buffer for clock tree synthesis
* Reduced truth table for output Y
* ┌─────┬─────┐
* │   A │   Y │
* ├─────┼─────┤
* │   1 │   1 │
* ├─────┼─────┤
* │   0 │   0 │
* └─────┴─────┘
****************************************
.SUBCKT CLKBUF_D4 A Y VDD VSS
*.PININFO A:I Y:O VDD:B VSS:B
MN0 n0 A VSS VSS sg13_lv_nmos w=3.6e-07 l=1.3e-07 ng=1
MP0 n0 A VDD VDD sg13_lv_pmos w=1.08e-06 l=1.3e-07 ng=1
MN1 Y n0 VSS VSS sg13_lv_nmos w=1e-06 l=1.3e-07 ng=2
MP1 Y n0 VDD VDD sg13_lv_pmos w=3e-06 l=1.3e-07 ng=2
.ENDS

****************************************
* Cell : CLKBUF_D6
* Description : Clock buffer for clock tree synthesis
* Reduced truth table for output Y
* ┌─────┬─────┐
* │   A │   Y │
* ├─────┼─────┤
* │   1 │   1 │
* ├─────┼─────┤
* │   0 │   0 │
* └─────┴─────┘
****************************************
.SUBCKT CLKBUF_D6 A Y VDD VSS
*.PININFO A:I Y:O VDD:B VSS:B
MN0 n0 A VSS VSS sg13_lv_nmos w=4.8e-07 l=1.3e-07 ng=1
MP0 n0 A VDD VDD sg13_lv_pmos w=1.44e-06 l=1.3e-07 ng=1
MN1 Y n0 VSS VSS sg13_lv_nmos w=1.3e-06 l=1.3e-07 ng=2
MP1 Y n0 VDD VDD sg13_lv_pmos w=3.9e-06 l=1.3e-07 ng=2
.ENDS

****************************************
* Cell : CLKBUF_D8
* Description : Clock buffer for clock tree synthesis
* Reduced truth table for output Y
* ┌─────┬─────┐
* │   A │   Y │
* ├─────┼─────┤
* │   1 │   1 │
* ├─────┼─────┤
* │   0 │   0 │
* └─────┴─────┘
****************************************
.SUBCKT CLKBUF_D8 A Y VDD VSS
*.PININFO A:I Y:O VDD:B VSS:B
MN0 n0 A VSS VSS sg13_lv_nmos w=7.6e-07 l=1.3e-07 ng=1
MP0 n0 A VDD VDD sg13_lv_pmos w=2.28e-06 l=1.3e-07 ng=1
MN1 Y n0 VSS VSS sg13_lv_nmos w=2.2e-06 l=1.3e-07 ng=4
MP1 Y n0 VDD VDD sg13_lv_pmos w=6.6e-06 l=1.3e-07 ng=4
.ENDS

****************************************
* Cell : CLKINV_D1
* Description : Inverter for clock signals
* Reduced truth table for output Y
* ┌─────┬─────┐
* │   A │   Y │
* ├─────┼─────┤
* │   0 │   1 │
* ├─────┼─────┤
* │   1 │   0 │
* └─────┴─────┘
****************************************
.SUBCKT CLKINV_D1 A Y VDD VSS
*.PININFO A:I Y:O VDD:B VSS:B
MN0 Y A VSS VSS sg13_lv_nmos w=3.4e-07 l=1.3e-07 ng=1
MP0 Y A VDD VDD sg13_lv_pmos w=9.8e-07 l=1.3e-07 ng=1
.ENDS

****************************************
* Cell : CLKINV_D16
* Description : Inverter for clock signals
* Reduced truth table for output Y
* ┌─────┬─────┐
* │   A │   Y │
* ├─────┼─────┤
* │   0 │   1 │
* ├─────┼─────┤
* │   1 │   0 │
* └─────┴─────┘
****************************************
.SUBCKT CLKINV_D16 A Y VDD VSS
*.PININFO A:I Y:O VDD:B VSS:B
MN0 Y A VSS VSS sg13_lv_nmos w=4e-06 l=1.3e-07 ng=8
MP0 Y A VDD VDD sg13_lv_pmos w=1.2e-05 l=1.3e-07 ng=8
.ENDS

****************************************
* Cell : CLKINV_D2
* Description : Inverter for clock signals
* Reduced truth table for output Y
* ┌─────┬─────┐
* │   A │   Y │
* ├─────┼─────┤
* │   0 │   1 │
* ├─────┼─────┤
* │   1 │   0 │
* └─────┴─────┘
****************************************
.SUBCKT CLKINV_D2 A Y VDD VSS
*.PININFO A:I Y:O VDD:B VSS:B
MN0 Y A VSS VSS sg13_lv_nmos w=5e-07 l=1.3e-07 ng=1
MP0 Y A VDD VDD sg13_lv_pmos w=1.5e-06 l=1.3e-07 ng=1
.ENDS

****************************************
* Cell : CLKINV_D4
* Description : Inverter for clock signals
* Reduced truth table for output Y
* ┌─────┬─────┐
* │   A │   Y │
* ├─────┼─────┤
* │   0 │   1 │
* ├─────┼─────┤
* │   1 │   0 │
* └─────┴─────┘
****************************************
.SUBCKT CLKINV_D4 A Y VDD VSS
*.PININFO A:I Y:O VDD:B VSS:B
MN0 Y A VSS VSS sg13_lv_nmos w=1e-06 l=1.3e-07 ng=2
MP0 Y A VDD VDD sg13_lv_pmos w=3e-06 l=1.3e-07 ng=2
.ENDS

****************************************
* Cell : CLKINV_D8
* Description : Inverter for clock signals
* Reduced truth table for output Y
* ┌─────┬─────┐
* │   A │   Y │
* ├─────┼─────┤
* │   0 │   1 │
* ├─────┼─────┤
* │   1 │   0 │
* └─────┴─────┘
****************************************
.SUBCKT CLKINV_D8 A Y VDD VSS
*.PININFO A:I Y:O VDD:B VSS:B
MN0 Y A VSS VSS sg13_lv_nmos w=2e-06 l=1.3e-07 ng=4
MP0 Y A VDD VDD sg13_lv_pmos w=6e-06 l=1.3e-07 ng=4
.ENDS

****************************************
* Cell : DFARQN_D1
* Description : D flip-flop with asynchronous reset and output QN.
* ┌───────┬─────┬──────┬──────┬───────────────┐
* │ CLK   │ D   │   RN │   QN │ Description   │
* ├───────┼─────┼──────┼──────┼───────────────┤
* │ R     │ 0   │    1 │    1 │ Write 0       │
* ├───────┼─────┼──────┼──────┼───────────────┤
* │ R     │ 1   │    1 │    0 │ Write 1       │
* ├───────┼─────┼──────┼──────┼───────────────┤
* │ -     │ -   │    0 │    1 │ Clear         │
* └───────┴─────┴──────┴──────┴───────────────┘
****************************************
.SUBCKT DFARQN_D1 D CLK QN RN VDD VSS
*.PININFO CLK:I D:I RN:I QN:O VDD:B VSS:B
MN0 n0 CLK VSS VSS sg13_lv_nmos w=3e-07 l=1.3e-07 ng=1
MP0 n0 CLK VDD VDD sg13_lv_pmos w=4.5e-07 l=1.3e-07 ng=1
MN1 n1 n0 VSS VSS sg13_lv_nmos w=2e-07 l=1.3e-07 ng=1
MP1 n1 n0 VDD VDD sg13_lv_pmos w=3e-07 l=1.3e-07 ng=1
MN2 n2 RN VSS VSS sg13_lv_nmos w=2e-07 l=1.3e-07 ng=1
MP2 n2 RN VDD VDD sg13_lv_pmos w=3e-07 l=1.3e-07 ng=1
MN3 n3 D n4 VSS sg13_lv_nmos w=1.5e-07 l=1.3e-07 ng=1
MN4 n4 n0 VSS VSS sg13_lv_nmos w=1.5e-07 l=1.3e-07 ng=1
MP3 n3 D n5 VDD sg13_lv_pmos w=2.3e-07 l=1.3e-07 ng=1
MP4 n5 n1 VDD VDD sg13_lv_pmos w=2.3e-07 l=1.3e-07 ng=1
MN5 n6 n3 VSS VSS sg13_lv_nmos w=3e-07 l=1.3e-07 ng=1
MN6 n6 n2 VSS VSS sg13_lv_nmos w=3e-07 l=1.3e-07 ng=1
MP5 n7 n3 VDD VDD sg13_lv_pmos w=4e-07 l=1.3e-07 ng=1
MP6 n6 n2 n7 VDD sg13_lv_pmos w=4e-07 l=1.3e-07 ng=1
MN7 n3 n1 n8 VSS sg13_lv_nmos w=1.5e-07 l=1.3e-07 ng=1
MN8 n8 n6 VSS VSS sg13_lv_nmos w=1.5e-07 l=1.3e-07 ng=1
MP7 n3 n0 n9 VDD sg13_lv_pmos w=2.3e-07 l=1.3e-07 ng=1
MP8 n9 n6 VDD VDD sg13_lv_pmos w=2.3e-07 l=1.3e-07 ng=1
MN9 n10 n1 n11 VSS sg13_lv_nmos w=5e-07 l=1.3e-07 ng=1
MN10 n11 n6 VSS VSS sg13_lv_nmos w=5e-07 l=1.3e-07 ng=1
MP9 n10 n0 n12 VDD sg13_lv_pmos w=7.5e-07 l=1.3e-07 ng=1
MP10 n12 n6 VDD VDD sg13_lv_pmos w=7.5e-07 l=1.3e-07 ng=1
MN11 n13 n10 VSS VSS sg13_lv_nmos w=4.5e-07 l=1.3e-07 ng=1
MN12 n13 n2 VSS VSS sg13_lv_nmos w=4.5e-07 l=1.3e-07 ng=1
MP11 n14 n10 VDD VDD sg13_lv_pmos w=4.5e-07 l=1.3e-07 ng=1
MP12 n13 n2 n14 VDD sg13_lv_pmos w=4.5e-07 l=1.3e-07 ng=1
MN13 n10 n0 n15 VSS sg13_lv_nmos w=1.5e-07 l=1.3e-07 ng=1
MN14 n15 n13 VSS VSS sg13_lv_nmos w=1.5e-07 l=1.3e-07 ng=1
MP13 n10 n1 n16 VDD sg13_lv_pmos w=1.5e-07 l=1.3e-07 ng=1
MP14 n16 n13 VDD VDD sg13_lv_pmos w=1.5e-07 l=1.3e-07 ng=1
MN15 QN n13 VSS VSS sg13_lv_nmos w=6.4e-07 l=1.3e-07 ng=1
MP15 QN n13 VDD VDD sg13_lv_pmos w=9.8e-07 l=1.3e-07 ng=1
.ENDS

****************************************
* Cell : DFARQN_DL
* Description : D flip-flop with asynchronous reset and output QN.
* ┌───────┬─────┬──────┬──────┬───────────────┐
* │ CLK   │ D   │   RN │   QN │ Description   │
* ├───────┼─────┼──────┼──────┼───────────────┤
* │ R     │ 0   │    1 │    1 │ Write 0       │
* ├───────┼─────┼──────┼──────┼───────────────┤
* │ R     │ 1   │    1 │    0 │ Write 1       │
* ├───────┼─────┼──────┼──────┼───────────────┤
* │ -     │ -   │    0 │    1 │ Clear         │
* └───────┴─────┴──────┴──────┴───────────────┘
****************************************
.SUBCKT DFARQN_DL D CLK QN RN VDD VSS
*.PININFO CLK:I D:I RN:I QN:O VDD:B VSS:B
MN0 n0 CLK VSS VSS sg13_lv_nmos w=2e-07 l=1.3e-07 ng=1
MP0 n0 CLK VDD VDD sg13_lv_pmos w=3e-07 l=1.3e-07 ng=1
MN1 n1 n0 VSS VSS sg13_lv_nmos w=2e-07 l=1.3e-07 ng=1
MP1 n1 n0 VDD VDD sg13_lv_pmos w=3e-07 l=1.3e-07 ng=1
MN2 n2 RN VSS VSS sg13_lv_nmos w=2e-07 l=1.3e-07 ng=1
MP2 n2 RN VDD VDD sg13_lv_pmos w=3e-07 l=1.3e-07 ng=1
MN3 n3 D n4 VSS sg13_lv_nmos w=1.5e-07 l=1.3e-07 ng=1
MN4 n4 n0 VSS VSS sg13_lv_nmos w=1.5e-07 l=1.3e-07 ng=1
MP3 n3 D n5 VDD sg13_lv_pmos w=2.3e-07 l=1.3e-07 ng=1
MP4 n5 n1 VDD VDD sg13_lv_pmos w=2.3e-07 l=1.3e-07 ng=1
MN5 n6 n3 VSS VSS sg13_lv_nmos w=3e-07 l=1.3e-07 ng=1
MN6 n6 n2 VSS VSS sg13_lv_nmos w=3e-07 l=1.3e-07 ng=1
MP5 n7 n3 VDD VDD sg13_lv_pmos w=3e-07 l=1.3e-07 ng=1
MP6 n6 n2 n7 VDD sg13_lv_pmos w=3e-07 l=1.3e-07 ng=1
MN7 n3 n1 n8 VSS sg13_lv_nmos w=1.5e-07 l=1.3e-07 ng=1
MN8 n8 n6 VSS VSS sg13_lv_nmos w=1.5e-07 l=1.3e-07 ng=1
MP7 n3 n0 n9 VDD sg13_lv_pmos w=2.3e-07 l=1.3e-07 ng=1
MP8 n9 n6 VDD VDD sg13_lv_pmos w=2.3e-07 l=1.3e-07 ng=1
MN9 n10 n1 n11 VSS sg13_lv_nmos w=2e-07 l=1.3e-07 ng=1
MN10 n11 n6 VSS VSS sg13_lv_nmos w=2e-07 l=1.3e-07 ng=1
MP9 n10 n0 n12 VDD sg13_lv_pmos w=3e-07 l=1.3e-07 ng=1
MP10 n12 n6 VDD VDD sg13_lv_pmos w=3e-07 l=1.3e-07 ng=1
MN11 n13 n10 VSS VSS sg13_lv_nmos w=3e-07 l=1.3e-07 ng=1
MN12 n13 n2 VSS VSS sg13_lv_nmos w=3e-07 l=1.3e-07 ng=1
MP11 n14 n10 VDD VDD sg13_lv_pmos w=3e-07 l=1.3e-07 ng=1
MP12 n13 n2 n14 VDD sg13_lv_pmos w=3e-07 l=1.3e-07 ng=1
MN13 n10 n0 n15 VSS sg13_lv_nmos w=1.5e-07 l=1.3e-07 ng=1
MN14 n15 n13 VSS VSS sg13_lv_nmos w=1.5e-07 l=1.3e-07 ng=1
MP13 n10 n1 n16 VDD sg13_lv_pmos w=1.5e-07 l=1.3e-07 ng=1
MP14 n16 n13 VDD VDD sg13_lv_pmos w=1.5e-07 l=1.3e-07 ng=1
MN15 QN n13 VSS VSS sg13_lv_nmos w=3.2e-07 l=1.3e-07 ng=1
MP15 QN n13 VDD VDD sg13_lv_pmos w=4.9e-07 l=1.3e-07 ng=1
.ENDS

****************************************
* Cell : DFARQQN_D1
* Description : D flip-flop with asynchronous reset and outputs Q and QN.
* ┌───────┬─────┬──────┬─────┬──────┬───────────────┐
* │ CLK   │ D   │   RN │   Q │   QN │ Description   │
* ├───────┼─────┼──────┼─────┼──────┼───────────────┤
* │ R     │ 0   │    1 │   0 │    1 │ Write 0       │
* ├───────┼─────┼──────┼─────┼──────┼───────────────┤
* │ R     │ 1   │    1 │   1 │    0 │ Write 1       │
* ├───────┼─────┼──────┼─────┼──────┼───────────────┤
* │ -     │ -   │    0 │   0 │    1 │ Clear         │
* └───────┴─────┴──────┴─────┴──────┴───────────────┘
****************************************
.SUBCKT DFARQQN_D1 D CLK Q QN RN VDD VSS
*.PININFO CLK:I D:I RN:I Q:O QN:O VDD:B VSS:B
MN0 n0 CLK VSS VSS sg13_lv_nmos w=3e-07 l=1.3e-07 ng=1
MP0 n0 CLK VDD VDD sg13_lv_pmos w=4.5e-07 l=1.3e-07 ng=1
MN1 n1 n0 VSS VSS sg13_lv_nmos w=2e-07 l=1.3e-07 ng=1
MP1 n1 n0 VDD VDD sg13_lv_pmos w=3e-07 l=1.3e-07 ng=1
MN2 n2 RN VSS VSS sg13_lv_nmos w=3e-07 l=1.3e-07 ng=1
MP2 n2 RN VDD VDD sg13_lv_pmos w=4.5e-07 l=1.3e-07 ng=1
MN3 n3 D n4 VSS sg13_lv_nmos w=1.5e-07 l=1.3e-07 ng=1
MN4 n4 n0 VSS VSS sg13_lv_nmos w=1.5e-07 l=1.3e-07 ng=1
MP3 n3 D n5 VDD sg13_lv_pmos w=2.3e-07 l=1.3e-07 ng=1
MP4 n5 n1 VDD VDD sg13_lv_pmos w=2.3e-07 l=1.3e-07 ng=1
MN5 n6 n3 VSS VSS sg13_lv_nmos w=2e-07 l=1.3e-07 ng=1
MN6 n6 n2 VSS VSS sg13_lv_nmos w=2e-07 l=1.3e-07 ng=1
MP5 n7 n3 VDD VDD sg13_lv_pmos w=4e-07 l=1.3e-07 ng=1
MP6 n6 n2 n7 VDD sg13_lv_pmos w=4e-07 l=1.3e-07 ng=1
MN7 n3 n1 n8 VSS sg13_lv_nmos w=1.5e-07 l=1.3e-07 ng=1
MN8 n8 n6 VSS VSS sg13_lv_nmos w=1.5e-07 l=1.3e-07 ng=1
MP7 n3 n0 n9 VDD sg13_lv_pmos w=2.3e-07 l=1.3e-07 ng=1
MP8 n9 n6 VDD VDD sg13_lv_pmos w=2.3e-07 l=1.3e-07 ng=1
MN9 n10 n1 n11 VSS sg13_lv_nmos w=5e-07 l=1.3e-07 ng=1
MN10 n11 n6 VSS VSS sg13_lv_nmos w=5e-07 l=1.3e-07 ng=1
MP9 n10 n0 n12 VDD sg13_lv_pmos w=7.5e-07 l=1.3e-07 ng=1
MP10 n12 n6 VDD VDD sg13_lv_pmos w=7.5e-07 l=1.3e-07 ng=1
MN11 n13 n10 VSS VSS sg13_lv_nmos w=3e-07 l=1.3e-07 ng=1
MN12 n13 n2 VSS VSS sg13_lv_nmos w=3e-07 l=1.3e-07 ng=1
MP11 n14 n10 VDD VDD sg13_lv_pmos w=6e-07 l=1.3e-07 ng=1
MP12 n13 n2 n14 VDD sg13_lv_pmos w=6e-07 l=1.3e-07 ng=1
MN13 n10 n0 n15 VSS sg13_lv_nmos w=1.5e-07 l=1.3e-07 ng=1
MN14 n15 n13 VSS VSS sg13_lv_nmos w=1.5e-07 l=1.3e-07 ng=1
MP13 n10 n1 n16 VDD sg13_lv_pmos w=1.5e-07 l=1.3e-07 ng=1
MP14 n16 n13 VDD VDD sg13_lv_pmos w=1.5e-07 l=1.3e-07 ng=1
MN15 n17 n13 VSS VSS sg13_lv_nmos w=2e-07 l=1.3e-07 ng=1
MP15 n17 n13 VDD VDD sg13_lv_pmos w=3e-07 l=1.3e-07 ng=1
MN16 Q n17 VSS VSS sg13_lv_nmos w=6.4e-07 l=1.3e-07 ng=1
MP16 Q n17 VDD VDD sg13_lv_pmos w=9.8e-07 l=1.3e-07 ng=1
MN17 QN n13 VSS VSS sg13_lv_nmos w=6.4e-07 l=1.3e-07 ng=1
MP17 QN n13 VDD VDD sg13_lv_pmos w=9.8e-07 l=1.3e-07 ng=1
.ENDS

****************************************
* Cell : DFARQQN_DL
* Description : D flip-flop with asynchronous reset and outputs Q and QN.
* ┌───────┬─────┬──────┬─────┬──────┬───────────────┐
* │ CLK   │ D   │   RN │   Q │   QN │ Description   │
* ├───────┼─────┼──────┼─────┼──────┼───────────────┤
* │ R     │ 0   │    1 │   0 │    1 │ Write 0       │
* ├───────┼─────┼──────┼─────┼──────┼───────────────┤
* │ R     │ 1   │    1 │   1 │    0 │ Write 1       │
* ├───────┼─────┼──────┼─────┼──────┼───────────────┤
* │ -     │ -   │    0 │   0 │    1 │ Clear         │
* └───────┴─────┴──────┴─────┴──────┴───────────────┘
****************************************
.SUBCKT DFARQQN_DL D CLK Q QN RN VDD VSS
*.PININFO CLK:I D:I RN:I Q:O QN:O VDD:B VSS:B
MN0 n0 CLK VSS VSS sg13_lv_nmos w=2e-07 l=1.3e-07 ng=1
MP0 n0 CLK VDD VDD sg13_lv_pmos w=3e-07 l=1.3e-07 ng=1
MN1 n1 n0 VSS VSS sg13_lv_nmos w=2e-07 l=1.3e-07 ng=1
MP1 n1 n0 VDD VDD sg13_lv_pmos w=3e-07 l=1.3e-07 ng=1
MN2 n2 RN VSS VSS sg13_lv_nmos w=2e-07 l=1.3e-07 ng=1
MP2 n2 RN VDD VDD sg13_lv_pmos w=3e-07 l=1.3e-07 ng=1
MN3 n3 D n4 VSS sg13_lv_nmos w=1.5e-07 l=1.3e-07 ng=1
MN4 n4 n0 VSS VSS sg13_lv_nmos w=1.5e-07 l=1.3e-07 ng=1
MP3 n3 D n5 VDD sg13_lv_pmos w=2.3e-07 l=1.3e-07 ng=1
MP4 n5 n1 VDD VDD sg13_lv_pmos w=2.3e-07 l=1.3e-07 ng=1
MN5 n6 n3 VSS VSS sg13_lv_nmos w=2e-07 l=1.3e-07 ng=1
MN6 n6 n2 VSS VSS sg13_lv_nmos w=2e-07 l=1.3e-07 ng=1
MP5 n7 n3 VDD VDD sg13_lv_pmos w=4e-07 l=1.3e-07 ng=1
MP6 n6 n2 n7 VDD sg13_lv_pmos w=4e-07 l=1.3e-07 ng=1
MN7 n3 n1 n8 VSS sg13_lv_nmos w=1.5e-07 l=1.3e-07 ng=1
MN8 n8 n6 VSS VSS sg13_lv_nmos w=1.5e-07 l=1.3e-07 ng=1
MP7 n3 n0 n9 VDD sg13_lv_pmos w=2.3e-07 l=1.3e-07 ng=1
MP8 n9 n6 VDD VDD sg13_lv_pmos w=2.3e-07 l=1.3e-07 ng=1
MN9 n10 n1 n11 VSS sg13_lv_nmos w=3e-07 l=1.3e-07 ng=1
MN10 n11 n6 VSS VSS sg13_lv_nmos w=3e-07 l=1.3e-07 ng=1
MP9 n10 n0 n12 VDD sg13_lv_pmos w=4.5e-07 l=1.3e-07 ng=1
MP10 n12 n6 VDD VDD sg13_lv_pmos w=4.5e-07 l=1.3e-07 ng=1
MN11 n13 n10 VSS VSS sg13_lv_nmos w=2e-07 l=1.3e-07 ng=1
MN12 n13 n2 VSS VSS sg13_lv_nmos w=2e-07 l=1.3e-07 ng=1
MP11 n14 n10 VDD VDD sg13_lv_pmos w=4e-07 l=1.3e-07 ng=1
MP12 n13 n2 n14 VDD sg13_lv_pmos w=4e-07 l=1.3e-07 ng=1
MN13 n10 n0 n15 VSS sg13_lv_nmos w=1.5e-07 l=1.3e-07 ng=1
MN14 n15 n13 VSS VSS sg13_lv_nmos w=1.5e-07 l=1.3e-07 ng=1
MP13 n10 n1 n16 VDD sg13_lv_pmos w=1.5e-07 l=1.3e-07 ng=1
MP14 n16 n13 VDD VDD sg13_lv_pmos w=1.5e-07 l=1.3e-07 ng=1
MN15 n17 n13 VSS VSS sg13_lv_nmos w=1.5e-07 l=1.3e-07 ng=1
MP15 n17 n13 VDD VDD sg13_lv_pmos w=2.3e-07 l=1.3e-07 ng=1
MN16 QN n13 VSS VSS sg13_lv_nmos w=3.2e-07 l=1.3e-07 ng=1
MP16 QN n13 VDD VDD sg13_lv_pmos w=4.9e-07 l=1.3e-07 ng=1
MN17 Q n17 VSS VSS sg13_lv_nmos w=3.2e-07 l=1.3e-07 ng=1
MP17 Q n17 VDD VDD sg13_lv_pmos w=4.9e-07 l=1.3e-07 ng=1
.ENDS

****************************************
* Cell : DFARQ_D1
* Description : D flip-flop with asynchronous reset and output Q.
* ┌───────┬─────┬──────┬─────┬───────────────┐
* │ CLK   │ D   │   RN │   Q │ Description   │
* ├───────┼─────┼──────┼─────┼───────────────┤
* │ R     │ 0   │    1 │   0 │ Write 0       │
* ├───────┼─────┼──────┼─────┼───────────────┤
* │ R     │ 1   │    1 │   1 │ Write 1       │
* ├───────┼─────┼──────┼─────┼───────────────┤
* │ -     │ -   │    0 │   0 │ Clear         │
* └───────┴─────┴──────┴─────┴───────────────┘
****************************************
.SUBCKT DFARQ_D1 D CLK Q RN VDD VSS
*.PININFO CLK:I D:I RN:I Q:O VDD:B VSS:B
MN0 n0 CLK VSS VSS sg13_lv_nmos w=3e-07 l=1.3e-07 ng=1
MP0 n0 CLK VDD VDD sg13_lv_pmos w=4.5e-07 l=1.3e-07 ng=1
MN1 n1 n0 VSS VSS sg13_lv_nmos w=3e-07 l=1.3e-07 ng=1
MP1 n1 n0 VDD VDD sg13_lv_pmos w=3e-07 l=1.3e-07 ng=1
MN2 n2 RN VSS VSS sg13_lv_nmos w=3e-07 l=1.3e-07 ng=1
MP2 n2 RN VDD VDD sg13_lv_pmos w=3e-07 l=1.3e-07 ng=1
MN3 n3 D n4 VSS sg13_lv_nmos w=1.5e-07 l=1.3e-07 ng=1
MN4 n4 n0 VSS VSS sg13_lv_nmos w=1.5e-07 l=1.3e-07 ng=1
MP3 n3 D n5 VDD sg13_lv_pmos w=2.3e-07 l=1.3e-07 ng=1
MP4 n5 n1 VDD VDD sg13_lv_pmos w=2.3e-07 l=1.3e-07 ng=1
MN5 n6 n3 VSS VSS sg13_lv_nmos w=3e-07 l=1.3e-07 ng=1
MN6 n6 n2 VSS VSS sg13_lv_nmos w=3e-07 l=1.3e-07 ng=1
MP5 n7 n3 VDD VDD sg13_lv_pmos w=4e-07 l=1.3e-07 ng=1
MP6 n6 n2 n7 VDD sg13_lv_pmos w=4e-07 l=1.3e-07 ng=1
MN7 n3 n1 n8 VSS sg13_lv_nmos w=1.5e-07 l=1.3e-07 ng=1
MN8 n8 n6 VSS VSS sg13_lv_nmos w=1.5e-07 l=1.3e-07 ng=1
MP7 n3 n0 n9 VDD sg13_lv_pmos w=2.3e-07 l=1.3e-07 ng=1
MP8 n9 n6 VDD VDD sg13_lv_pmos w=2.3e-07 l=1.3e-07 ng=1
MN9 n10 n1 n11 VSS sg13_lv_nmos w=3e-07 l=1.3e-07 ng=1
MN10 n11 n6 VSS VSS sg13_lv_nmos w=3e-07 l=1.3e-07 ng=1
MP9 n10 n0 n12 VDD sg13_lv_pmos w=3e-07 l=1.3e-07 ng=1
MP10 n12 n6 VDD VDD sg13_lv_pmos w=3e-07 l=1.3e-07 ng=1
MN11 n13 n10 VSS VSS sg13_lv_nmos w=3e-07 l=1.3e-07 ng=1
MN12 n13 n2 VSS VSS sg13_lv_nmos w=3e-07 l=1.3e-07 ng=1
MP11 n14 n10 VDD VDD sg13_lv_pmos w=3e-07 l=1.3e-07 ng=1
MP12 n13 n2 n14 VDD sg13_lv_pmos w=3e-07 l=1.3e-07 ng=1
MN13 n10 n0 n15 VSS sg13_lv_nmos w=1.5e-07 l=1.3e-07 ng=1
MN14 n15 n13 VSS VSS sg13_lv_nmos w=1.5e-07 l=1.3e-07 ng=1
MP13 n10 n1 n16 VDD sg13_lv_pmos w=1.5e-07 l=1.3e-07 ng=1
MP14 n16 n13 VDD VDD sg13_lv_pmos w=1.5e-07 l=1.3e-07 ng=1
MN15 n17 n13 VSS VSS sg13_lv_nmos w=3e-07 l=1.3e-07 ng=1
MP15 n17 n13 VDD VDD sg13_lv_pmos w=4.5e-07 l=1.3e-07 ng=1
MN16 Q n17 VSS VSS sg13_lv_nmos w=6.4e-07 l=1.3e-07 ng=1
MP16 Q n17 VDD VDD sg13_lv_pmos w=9.8e-07 l=1.3e-07 ng=1
.ENDS

****************************************
* Cell : DFARQ_DL
* Description : D flip-flop with asynchronous reset and output Q.
* ┌───────┬─────┬──────┬─────┬───────────────┐
* │ CLK   │ D   │   RN │   Q │ Description   │
* ├───────┼─────┼──────┼─────┼───────────────┤
* │ R     │ 0   │    1 │   0 │ Write 0       │
* ├───────┼─────┼──────┼─────┼───────────────┤
* │ R     │ 1   │    1 │   1 │ Write 1       │
* ├───────┼─────┼──────┼─────┼───────────────┤
* │ -     │ -   │    0 │   0 │ Clear         │
* └───────┴─────┴──────┴─────┴───────────────┘
****************************************
.SUBCKT DFARQ_DL D CLK Q RN VDD VSS
*.PININFO CLK:I D:I RN:I Q:O VDD:B VSS:B
MN0 n0 CLK VSS VSS sg13_lv_nmos w=2e-07 l=1.3e-07 ng=1
MP0 n0 CLK VDD VDD sg13_lv_pmos w=3e-07 l=1.3e-07 ng=1
MN1 n1 n0 VSS VSS sg13_lv_nmos w=2e-07 l=1.3e-07 ng=1
MP1 n1 n0 VDD VDD sg13_lv_pmos w=3e-07 l=1.3e-07 ng=1
MN2 n2 RN VSS VSS sg13_lv_nmos w=2e-07 l=1.3e-07 ng=1
MP2 n2 RN VDD VDD sg13_lv_pmos w=3e-07 l=1.3e-07 ng=1
MN3 n3 D n4 VSS sg13_lv_nmos w=1.5e-07 l=1.3e-07 ng=1
MN4 n4 n0 VSS VSS sg13_lv_nmos w=1.5e-07 l=1.3e-07 ng=1
MP3 n3 D n5 VDD sg13_lv_pmos w=2.3e-07 l=1.3e-07 ng=1
MP4 n5 n1 VDD VDD sg13_lv_pmos w=2.3e-07 l=1.3e-07 ng=1
MN5 n6 n3 VSS VSS sg13_lv_nmos w=3e-07 l=1.3e-07 ng=1
MN6 n6 n2 VSS VSS sg13_lv_nmos w=3e-07 l=1.3e-07 ng=1
MP5 n7 n3 VDD VDD sg13_lv_pmos w=4e-07 l=1.3e-07 ng=1
MP6 n6 n2 n7 VDD sg13_lv_pmos w=4e-07 l=1.3e-07 ng=1
MN7 n3 n1 n8 VSS sg13_lv_nmos w=1.5e-07 l=1.3e-07 ng=1
MN8 n8 n6 VSS VSS sg13_lv_nmos w=1.5e-07 l=1.3e-07 ng=1
MP7 n3 n0 n9 VDD sg13_lv_pmos w=2.3e-07 l=1.3e-07 ng=1
MP8 n9 n6 VDD VDD sg13_lv_pmos w=2.3e-07 l=1.3e-07 ng=1
MN9 n10 n1 n11 VSS sg13_lv_nmos w=2e-07 l=1.3e-07 ng=1
MN10 n11 n6 VSS VSS sg13_lv_nmos w=2e-07 l=1.3e-07 ng=1
MP9 n10 n0 n12 VDD sg13_lv_pmos w=3e-07 l=1.3e-07 ng=1
MP10 n12 n6 VDD VDD sg13_lv_pmos w=3e-07 l=1.3e-07 ng=1
MN11 n13 n10 VSS VSS sg13_lv_nmos w=3e-07 l=1.3e-07 ng=1
MN12 n13 n2 VSS VSS sg13_lv_nmos w=3e-07 l=1.3e-07 ng=1
MP11 n14 n10 VDD VDD sg13_lv_pmos w=3e-07 l=1.3e-07 ng=1
MP12 n13 n2 n14 VDD sg13_lv_pmos w=3e-07 l=1.3e-07 ng=1
MN13 n10 n0 n15 VSS sg13_lv_nmos w=1.5e-07 l=1.3e-07 ng=1
MN14 n15 n13 VSS VSS sg13_lv_nmos w=1.5e-07 l=1.3e-07 ng=1
MP13 n10 n1 n16 VDD sg13_lv_pmos w=1.5e-07 l=1.3e-07 ng=1
MP14 n16 n13 VDD VDD sg13_lv_pmos w=1.5e-07 l=1.3e-07 ng=1
MN15 n17 n13 VSS VSS sg13_lv_nmos w=2e-07 l=1.3e-07 ng=1
MP15 n17 n13 VDD VDD sg13_lv_pmos w=3e-07 l=1.3e-07 ng=1
MN16 Q n17 VSS VSS sg13_lv_nmos w=3.2e-07 l=1.3e-07 ng=1
MP16 Q n17 VDD VDD sg13_lv_pmos w=4.9e-07 l=1.3e-07 ng=1
.ENDS

****************************************
* Cell : DFASQN_D1
* Description : D flip-flop with asynchronous set and output QN.
* ┌───────┬─────┬──────┬──────┬───────────────┐
* │ CLK   │ D   │   SN │   QN │ Description   │
* ├───────┼─────┼──────┼──────┼───────────────┤
* │ R     │ 0   │    1 │    1 │ Write 0       │
* ├───────┼─────┼──────┼──────┼───────────────┤
* │ R     │ 1   │    1 │    0 │ Write 1       │
* ├───────┼─────┼──────┼──────┼───────────────┤
* │ -     │ -   │    0 │    0 │ Set           │
* └───────┴─────┴──────┴──────┴───────────────┘
****************************************
.SUBCKT DFASQN_D1 D CLK QN SN VDD VSS
*.PININFO CLK:I D:I SN:I QN:O VDD:B VSS:B
MN0 n0 CLK VSS VSS sg13_lv_nmos w=3e-07 l=1.3e-07 ng=1
MP0 n0 CLK VDD VDD sg13_lv_pmos w=4.5e-07 l=1.3e-07 ng=1
MN1 n1 n0 VSS VSS sg13_lv_nmos w=2e-07 l=1.3e-07 ng=1
MP1 n1 n0 VDD VDD sg13_lv_pmos w=3e-07 l=1.3e-07 ng=1
MN2 n2 D n3 VSS sg13_lv_nmos w=1.5e-07 l=1.3e-07 ng=1
MN3 n3 n0 VSS VSS sg13_lv_nmos w=1.5e-07 l=1.3e-07 ng=1
MP2 n2 D n4 VDD sg13_lv_pmos w=2.3e-07 l=1.3e-07 ng=1
MP3 n4 n1 VDD VDD sg13_lv_pmos w=2.3e-07 l=1.3e-07 ng=1
MN4 n5 SN VSS VSS sg13_lv_nmos w=2e-07 l=1.3e-07 ng=1
MN5 n6 n2 n5 VSS sg13_lv_nmos w=2e-07 l=1.3e-07 ng=1
MP4 n6 SN VDD VDD sg13_lv_pmos w=2.2e-07 l=1.3e-07 ng=1
MP5 n6 n2 VDD VDD sg13_lv_pmos w=2.2e-07 l=1.3e-07 ng=1
MN6 n2 n1 n7 VSS sg13_lv_nmos w=1.5e-07 l=1.3e-07 ng=1
MN7 n7 n6 VSS VSS sg13_lv_nmos w=1.5e-07 l=1.3e-07 ng=1
MP6 n2 n0 n8 VDD sg13_lv_pmos w=2.3e-07 l=1.3e-07 ng=1
MP7 n8 n6 VDD VDD sg13_lv_pmos w=2.3e-07 l=1.3e-07 ng=1
MN8 n9 n1 n10 VSS sg13_lv_nmos w=5e-07 l=1.3e-07 ng=1
MN9 n10 n6 VSS VSS sg13_lv_nmos w=5e-07 l=1.3e-07 ng=1
MP8 n9 n0 n11 VDD sg13_lv_pmos w=7.5e-07 l=1.3e-07 ng=1
MP9 n11 n6 VDD VDD sg13_lv_pmos w=7.5e-07 l=1.3e-07 ng=1
MN10 n12 SN VSS VSS sg13_lv_nmos w=3e-07 l=1.3e-07 ng=1
MN11 n13 n9 n12 VSS sg13_lv_nmos w=3e-07 l=1.3e-07 ng=1
MP10 n13 SN VDD VDD sg13_lv_pmos w=3.3e-07 l=1.3e-07 ng=1
MP11 n13 n9 VDD VDD sg13_lv_pmos w=3.3e-07 l=1.3e-07 ng=1
MN12 n9 n0 n14 VSS sg13_lv_nmos w=1.5e-07 l=1.3e-07 ng=1
MN13 n14 n13 VSS VSS sg13_lv_nmos w=1.5e-07 l=1.3e-07 ng=1
MP12 n9 n1 n15 VDD sg13_lv_pmos w=1.5e-07 l=1.3e-07 ng=1
MP13 n15 n13 VDD VDD sg13_lv_pmos w=1.5e-07 l=1.3e-07 ng=1
MN14 QN n13 VSS VSS sg13_lv_nmos w=6.4e-07 l=1.3e-07 ng=1
MP14 QN n13 VDD VDD sg13_lv_pmos w=9.8e-07 l=1.3e-07 ng=1
.ENDS

****************************************
* Cell : DFASQN_DL
* Description : D flip-flop with asynchronous set and output QN.
* ┌───────┬─────┬──────┬──────┬───────────────┐
* │ CLK   │ D   │   SN │   QN │ Description   │
* ├───────┼─────┼──────┼──────┼───────────────┤
* │ R     │ 0   │    1 │    1 │ Write 0       │
* ├───────┼─────┼──────┼──────┼───────────────┤
* │ R     │ 1   │    1 │    0 │ Write 1       │
* ├───────┼─────┼──────┼──────┼───────────────┤
* │ -     │ -   │    0 │    0 │ Set           │
* └───────┴─────┴──────┴──────┴───────────────┘
****************************************
.SUBCKT DFASQN_DL D CLK QN SN VDD VSS
*.PININFO CLK:I D:I SN:I QN:O VDD:B VSS:B
MN0 n0 CLK VSS VSS sg13_lv_nmos w=2e-07 l=1.3e-07 ng=1
MP0 n0 CLK VDD VDD sg13_lv_pmos w=3e-07 l=1.3e-07 ng=1
MN1 n1 n0 VSS VSS sg13_lv_nmos w=2e-07 l=1.3e-07 ng=1
MP1 n1 n0 VDD VDD sg13_lv_pmos w=3e-07 l=1.3e-07 ng=1
MN2 n2 D n3 VSS sg13_lv_nmos w=1.5e-07 l=1.3e-07 ng=1
MN3 n3 n0 VSS VSS sg13_lv_nmos w=1.5e-07 l=1.3e-07 ng=1
MP2 n2 D n4 VDD sg13_lv_pmos w=2.3e-07 l=1.3e-07 ng=1
MP3 n4 n1 VDD VDD sg13_lv_pmos w=2.3e-07 l=1.3e-07 ng=1
MN4 n5 SN VSS VSS sg13_lv_nmos w=2e-07 l=1.3e-07 ng=1
MN5 n6 n2 n5 VSS sg13_lv_nmos w=2e-07 l=1.3e-07 ng=1
MP4 n6 SN VDD VDD sg13_lv_pmos w=2.2e-07 l=1.3e-07 ng=1
MP5 n6 n2 VDD VDD sg13_lv_pmos w=2.2e-07 l=1.3e-07 ng=1
MN6 n2 n1 n7 VSS sg13_lv_nmos w=1.5e-07 l=1.3e-07 ng=1
MN7 n7 n6 VSS VSS sg13_lv_nmos w=1.5e-07 l=1.3e-07 ng=1
MP6 n2 n0 n8 VDD sg13_lv_pmos w=2.3e-07 l=1.3e-07 ng=1
MP7 n8 n6 VDD VDD sg13_lv_pmos w=2.3e-07 l=1.3e-07 ng=1
MN8 n9 n1 n10 VSS sg13_lv_nmos w=3e-07 l=1.3e-07 ng=1
MN9 n10 n6 VSS VSS sg13_lv_nmos w=3e-07 l=1.3e-07 ng=1
MP8 n9 n0 n11 VDD sg13_lv_pmos w=4.5e-07 l=1.3e-07 ng=1
MP9 n11 n6 VDD VDD sg13_lv_pmos w=4.5e-07 l=1.3e-07 ng=1
MN10 n12 SN VSS VSS sg13_lv_nmos w=2e-07 l=1.3e-07 ng=1
MN11 n13 n9 n12 VSS sg13_lv_nmos w=2e-07 l=1.3e-07 ng=1
MP10 n13 SN VDD VDD sg13_lv_pmos w=2.2e-07 l=1.3e-07 ng=1
MP11 n13 n9 VDD VDD sg13_lv_pmos w=2.2e-07 l=1.3e-07 ng=1
MN12 n9 n0 n14 VSS sg13_lv_nmos w=1.5e-07 l=1.3e-07 ng=1
MN13 n14 n13 VSS VSS sg13_lv_nmos w=1.5e-07 l=1.3e-07 ng=1
MP12 n9 n1 n15 VDD sg13_lv_pmos w=1.5e-07 l=1.3e-07 ng=1
MP13 n15 n13 VDD VDD sg13_lv_pmos w=1.5e-07 l=1.3e-07 ng=1
MN14 QN n13 VSS VSS sg13_lv_nmos w=3.2e-07 l=1.3e-07 ng=1
MP14 QN n13 VDD VDD sg13_lv_pmos w=4.8e-07 l=1.3e-07 ng=1
.ENDS

****************************************
* Cell : DFASQQN_D1
* Description : D flip-flop with asynchronous set and outputs Q and QN.
* ┌───────┬─────┬──────┬─────┬──────┬───────────────┐
* │ CLK   │ D   │   SN │   Q │   QN │ Description   │
* ├───────┼─────┼──────┼─────┼──────┼───────────────┤
* │ R     │ 0   │    1 │   0 │    1 │ Write 0       │
* ├───────┼─────┼──────┼─────┼──────┼───────────────┤
* │ R     │ 1   │    1 │   1 │    0 │ Write 1       │
* ├───────┼─────┼──────┼─────┼──────┼───────────────┤
* │ -     │ -   │    0 │   1 │    0 │ Set           │
* └───────┴─────┴──────┴─────┴──────┴───────────────┘
****************************************
.SUBCKT DFASQQN_D1 D CLK Q QN SN VDD VSS
*.PININFO CLK:I D:I SN:I Q:O QN:O VDD:B VSS:B
MN0 n0 CLK VSS VSS sg13_lv_nmos w=3e-07 l=1.3e-07 ng=1
MP0 n0 CLK VDD VDD sg13_lv_pmos w=4.5e-07 l=1.3e-07 ng=1
MN1 n1 n0 VSS VSS sg13_lv_nmos w=2e-07 l=1.3e-07 ng=1
MP1 n1 n0 VDD VDD sg13_lv_pmos w=3e-07 l=1.3e-07 ng=1
MN2 n2 D n3 VSS sg13_lv_nmos w=1.5e-07 l=1.3e-07 ng=1
MN3 n3 n0 VSS VSS sg13_lv_nmos w=1.5e-07 l=1.3e-07 ng=1
MP2 n2 D n4 VDD sg13_lv_pmos w=2.3e-07 l=1.3e-07 ng=1
MP3 n4 n1 VDD VDD sg13_lv_pmos w=2.3e-07 l=1.3e-07 ng=1
MN4 n5 SN VSS VSS sg13_lv_nmos w=2e-07 l=1.3e-07 ng=1
MN5 n6 n2 n5 VSS sg13_lv_nmos w=2e-07 l=1.3e-07 ng=1
MP4 n6 SN VDD VDD sg13_lv_pmos w=2.2e-07 l=1.3e-07 ng=1
MP5 n6 n2 VDD VDD sg13_lv_pmos w=2.2e-07 l=1.3e-07 ng=1
MN6 n2 n1 n7 VSS sg13_lv_nmos w=1.5e-07 l=1.3e-07 ng=1
MN7 n7 n6 VSS VSS sg13_lv_nmos w=1.5e-07 l=1.3e-07 ng=1
MP6 n2 n0 n8 VDD sg13_lv_pmos w=2.3e-07 l=1.3e-07 ng=1
MP7 n8 n6 VDD VDD sg13_lv_pmos w=2.3e-07 l=1.3e-07 ng=1
MN8 n9 n1 n10 VSS sg13_lv_nmos w=5e-07 l=1.3e-07 ng=1
MN9 n10 n6 VSS VSS sg13_lv_nmos w=5e-07 l=1.3e-07 ng=1
MP8 n9 n0 n11 VDD sg13_lv_pmos w=7.5e-07 l=1.3e-07 ng=1
MP9 n11 n6 VDD VDD sg13_lv_pmos w=7.5e-07 l=1.3e-07 ng=1
MN10 n12 SN VSS VSS sg13_lv_nmos w=3e-07 l=1.3e-07 ng=1
MN11 n13 n9 n12 VSS sg13_lv_nmos w=3e-07 l=1.3e-07 ng=1
MP10 n13 SN VDD VDD sg13_lv_pmos w=3.3e-07 l=1.3e-07 ng=1
MP11 n13 n9 VDD VDD sg13_lv_pmos w=3.3e-07 l=1.3e-07 ng=1
MN12 n9 n0 n14 VSS sg13_lv_nmos w=1.5e-07 l=1.3e-07 ng=1
MN13 n14 n13 VSS VSS sg13_lv_nmos w=1.5e-07 l=1.3e-07 ng=1
MP12 n9 n1 n15 VDD sg13_lv_pmos w=1.5e-07 l=1.3e-07 ng=1
MP13 n15 n13 VDD VDD sg13_lv_pmos w=1.5e-07 l=1.3e-07 ng=1
MN14 n16 n13 VSS VSS sg13_lv_nmos w=2e-07 l=1.3e-07 ng=1
MP14 n16 n13 VDD VDD sg13_lv_pmos w=3e-07 l=1.3e-07 ng=1
MN15 Q n16 VSS VSS sg13_lv_nmos w=6.4e-07 l=1.3e-07 ng=1
MP15 Q n16 VDD VDD sg13_lv_pmos w=9.8e-07 l=1.3e-07 ng=1
MN16 QN n13 VSS VSS sg13_lv_nmos w=6.4e-07 l=1.3e-07 ng=1
MP16 QN n13 VDD VDD sg13_lv_pmos w=9.8e-07 l=1.3e-07 ng=1
.ENDS

****************************************
* Cell : DFASQQN_DL
* Description : D flip-flop with asynchronous set and outputs Q and QN.
* ┌───────┬─────┬──────┬─────┬──────┬───────────────┐
* │ CLK   │ D   │   SN │   Q │   QN │ Description   │
* ├───────┼─────┼──────┼─────┼──────┼───────────────┤
* │ R     │ 0   │    1 │   0 │    1 │ Write 0       │
* ├───────┼─────┼──────┼─────┼──────┼───────────────┤
* │ R     │ 1   │    1 │   1 │    0 │ Write 1       │
* ├───────┼─────┼──────┼─────┼──────┼───────────────┤
* │ -     │ -   │    0 │   1 │    0 │ Set           │
* └───────┴─────┴──────┴─────┴──────┴───────────────┘
****************************************
.SUBCKT DFASQQN_DL D CLK Q QN SN VDD VSS
*.PININFO CLK:I D:I SN:I Q:O QN:O VDD:B VSS:B
MN0 n0 CLK VSS VSS sg13_lv_nmos w=2e-07 l=1.3e-07 ng=1
MP0 n0 CLK VDD VDD sg13_lv_pmos w=3e-07 l=1.3e-07 ng=1
MN1 n1 n0 VSS VSS sg13_lv_nmos w=2e-07 l=1.3e-07 ng=1
MP1 n1 n0 VDD VDD sg13_lv_pmos w=3e-07 l=1.3e-07 ng=1
MN2 n2 D n3 VSS sg13_lv_nmos w=1.5e-07 l=1.3e-07 ng=1
MN3 n3 n0 VSS VSS sg13_lv_nmos w=1.5e-07 l=1.3e-07 ng=1
MP2 n2 D n4 VDD sg13_lv_pmos w=2.3e-07 l=1.3e-07 ng=1
MP3 n4 n1 VDD VDD sg13_lv_pmos w=2.3e-07 l=1.3e-07 ng=1
MN4 n5 SN VSS VSS sg13_lv_nmos w=2e-07 l=1.3e-07 ng=1
MN5 n6 n2 n5 VSS sg13_lv_nmos w=2e-07 l=1.3e-07 ng=1
MP4 n6 SN VDD VDD sg13_lv_pmos w=2.2e-07 l=1.3e-07 ng=1
MP5 n6 n2 VDD VDD sg13_lv_pmos w=2.2e-07 l=1.3e-07 ng=1
MN6 n2 n1 n7 VSS sg13_lv_nmos w=1.5e-07 l=1.3e-07 ng=1
MN7 n7 n6 VSS VSS sg13_lv_nmos w=1.5e-07 l=1.3e-07 ng=1
MP6 n2 n0 n8 VDD sg13_lv_pmos w=2.3e-07 l=1.3e-07 ng=1
MP7 n8 n6 VDD VDD sg13_lv_pmos w=2.3e-07 l=1.3e-07 ng=1
MN8 n9 n1 n10 VSS sg13_lv_nmos w=3e-07 l=1.3e-07 ng=1
MN9 n10 n6 VSS VSS sg13_lv_nmos w=3e-07 l=1.3e-07 ng=1
MP8 n9 n0 n11 VDD sg13_lv_pmos w=4.5e-07 l=1.3e-07 ng=1
MP9 n11 n6 VDD VDD sg13_lv_pmos w=4.5e-07 l=1.3e-07 ng=1
MN10 n12 SN VSS VSS sg13_lv_nmos w=2e-07 l=1.3e-07 ng=1
MN11 n13 n9 n12 VSS sg13_lv_nmos w=2e-07 l=1.3e-07 ng=1
MP10 n13 SN VDD VDD sg13_lv_pmos w=2.2e-07 l=1.3e-07 ng=1
MP11 n13 n9 VDD VDD sg13_lv_pmos w=2.2e-07 l=1.3e-07 ng=1
MN12 n9 n0 n14 VSS sg13_lv_nmos w=1.5e-07 l=1.3e-07 ng=1
MN13 n14 n13 VSS VSS sg13_lv_nmos w=1.5e-07 l=1.3e-07 ng=1
MP12 n9 n1 n15 VDD sg13_lv_pmos w=1.5e-07 l=1.3e-07 ng=1
MP13 n15 n13 VDD VDD sg13_lv_pmos w=1.5e-07 l=1.3e-07 ng=1
MN14 n16 n13 VSS VSS sg13_lv_nmos w=2e-07 l=1.3e-07 ng=1
MP14 n16 n13 VDD VDD sg13_lv_pmos w=3e-07 l=1.3e-07 ng=1
MN15 Q n16 VSS VSS sg13_lv_nmos w=3.2e-07 l=1.3e-07 ng=1
MP15 Q n16 VDD VDD sg13_lv_pmos w=4.8e-07 l=1.3e-07 ng=1
MN16 QN n13 VSS VSS sg13_lv_nmos w=3.2e-07 l=1.3e-07 ng=1
MP16 QN n13 VDD VDD sg13_lv_pmos w=4.8e-07 l=1.3e-07 ng=1
.ENDS

****************************************
* Cell : DFASQ_D1
* Description : D flip-flop with asynchronous set and output Q.
* ┌───────┬─────┬──────┬─────┬───────────────┐
* │ CLK   │ D   │   SN │   Q │ Description   │
* ├───────┼─────┼──────┼─────┼───────────────┤
* │ R     │ 0   │    1 │   0 │ Write 0       │
* ├───────┼─────┼──────┼─────┼───────────────┤
* │ R     │ 1   │    1 │   1 │ Write 1       │
* ├───────┼─────┼──────┼─────┼───────────────┤
* │ -     │ -   │    0 │   1 │ Set           │
* └───────┴─────┴──────┴─────┴───────────────┘
****************************************
.SUBCKT DFASQ_D1 D CLK Q SN VDD VSS
*.PININFO CLK:I D:I SN:I Q:O VDD:B VSS:B
MN0 n0 CLK VSS VSS sg13_lv_nmos w=3e-07 l=1.3e-07 ng=1
MP0 n0 CLK VDD VDD sg13_lv_pmos w=4.5e-07 l=1.3e-07 ng=1
MN1 n1 n0 VSS VSS sg13_lv_nmos w=2e-07 l=1.3e-07 ng=1
MP1 n1 n0 VDD VDD sg13_lv_pmos w=3e-07 l=1.3e-07 ng=1
MN2 n2 D n3 VSS sg13_lv_nmos w=1.5e-07 l=1.3e-07 ng=1
MN3 n3 n0 VSS VSS sg13_lv_nmos w=1.5e-07 l=1.3e-07 ng=1
MP2 n2 D n4 VDD sg13_lv_pmos w=2.3e-07 l=1.3e-07 ng=1
MP3 n4 n1 VDD VDD sg13_lv_pmos w=2.3e-07 l=1.3e-07 ng=1
MN4 n5 SN VSS VSS sg13_lv_nmos w=2e-07 l=1.3e-07 ng=1
MN5 n6 n2 n5 VSS sg13_lv_nmos w=2e-07 l=1.3e-07 ng=1
MP4 n6 SN VDD VDD sg13_lv_pmos w=2.2e-07 l=1.3e-07 ng=1
MP5 n6 n2 VDD VDD sg13_lv_pmos w=2.2e-07 l=1.3e-07 ng=1
MN6 n2 n1 n7 VSS sg13_lv_nmos w=1.5e-07 l=1.3e-07 ng=1
MN7 n7 n6 VSS VSS sg13_lv_nmos w=1.5e-07 l=1.3e-07 ng=1
MP6 n2 n0 n8 VDD sg13_lv_pmos w=2.3e-07 l=1.3e-07 ng=1
MP7 n8 n6 VDD VDD sg13_lv_pmos w=2.3e-07 l=1.3e-07 ng=1
MN8 n9 n1 n10 VSS sg13_lv_nmos w=5e-07 l=1.3e-07 ng=1
MN9 n10 n6 VSS VSS sg13_lv_nmos w=5e-07 l=1.3e-07 ng=1
MP8 n9 n0 n11 VDD sg13_lv_pmos w=7.5e-07 l=1.3e-07 ng=1
MP9 n11 n6 VDD VDD sg13_lv_pmos w=7.5e-07 l=1.3e-07 ng=1
MN10 n12 SN VSS VSS sg13_lv_nmos w=3e-07 l=1.3e-07 ng=1
MN11 n13 n9 n12 VSS sg13_lv_nmos w=3e-07 l=1.3e-07 ng=1
MP10 n13 SN VDD VDD sg13_lv_pmos w=3.3e-07 l=1.3e-07 ng=1
MP11 n13 n9 VDD VDD sg13_lv_pmos w=3.3e-07 l=1.3e-07 ng=1
MN12 n9 n0 n14 VSS sg13_lv_nmos w=1.5e-07 l=1.3e-07 ng=1
MN13 n14 n13 VSS VSS sg13_lv_nmos w=1.5e-07 l=1.3e-07 ng=1
MP12 n9 n1 n15 VDD sg13_lv_pmos w=1.5e-07 l=1.3e-07 ng=1
MP13 n15 n13 VDD VDD sg13_lv_pmos w=1.5e-07 l=1.3e-07 ng=1
MN14 n16 n13 VSS VSS sg13_lv_nmos w=2e-07 l=1.3e-07 ng=1
MP14 n16 n13 VDD VDD sg13_lv_pmos w=3e-07 l=1.3e-07 ng=1
MN15 Q n16 VSS VSS sg13_lv_nmos w=6.4e-07 l=1.3e-07 ng=1
MP15 Q n16 VDD VDD sg13_lv_pmos w=9.8e-07 l=1.3e-07 ng=1
.ENDS

****************************************
* Cell : DFASQ_DL
* Description : D flip-flop with asynchronous set and output Q.
* ┌───────┬─────┬──────┬─────┬───────────────┐
* │ CLK   │ D   │   SN │   Q │ Description   │
* ├───────┼─────┼──────┼─────┼───────────────┤
* │ R     │ 0   │    1 │   0 │ Write 0       │
* ├───────┼─────┼──────┼─────┼───────────────┤
* │ R     │ 1   │    1 │   1 │ Write 1       │
* ├───────┼─────┼──────┼─────┼───────────────┤
* │ -     │ -   │    0 │   1 │ Set           │
* └───────┴─────┴──────┴─────┴───────────────┘
****************************************
.SUBCKT DFASQ_DL D CLK Q SN VDD VSS
*.PININFO CLK:I D:I SN:I Q:O VDD:B VSS:B
MN0 n0 CLK VSS VSS sg13_lv_nmos w=2e-07 l=1.3e-07 ng=1
MP0 n0 CLK VDD VDD sg13_lv_pmos w=3e-07 l=1.3e-07 ng=1
MN1 n1 n0 VSS VSS sg13_lv_nmos w=2e-07 l=1.3e-07 ng=1
MP1 n1 n0 VDD VDD sg13_lv_pmos w=3e-07 l=1.3e-07 ng=1
MN2 n2 D n3 VSS sg13_lv_nmos w=1.5e-07 l=1.3e-07 ng=1
MN3 n3 n0 VSS VSS sg13_lv_nmos w=1.5e-07 l=1.3e-07 ng=1
MP2 n2 D n4 VDD sg13_lv_pmos w=2.3e-07 l=1.3e-07 ng=1
MP3 n4 n1 VDD VDD sg13_lv_pmos w=2.3e-07 l=1.3e-07 ng=1
MN4 n5 SN VSS VSS sg13_lv_nmos w=2e-07 l=1.3e-07 ng=1
MN5 n6 n2 n5 VSS sg13_lv_nmos w=2e-07 l=1.3e-07 ng=1
MP4 n6 SN VDD VDD sg13_lv_pmos w=2.2e-07 l=1.3e-07 ng=1
MP5 n6 n2 VDD VDD sg13_lv_pmos w=2.2e-07 l=1.3e-07 ng=1
MN6 n2 n1 n7 VSS sg13_lv_nmos w=1.5e-07 l=1.3e-07 ng=1
MN7 n7 n6 VSS VSS sg13_lv_nmos w=1.5e-07 l=1.3e-07 ng=1
MP6 n2 n0 n8 VDD sg13_lv_pmos w=2.3e-07 l=1.3e-07 ng=1
MP7 n8 n6 VDD VDD sg13_lv_pmos w=2.3e-07 l=1.3e-07 ng=1
MN8 n9 n1 n10 VSS sg13_lv_nmos w=3e-07 l=1.3e-07 ng=1
MN9 n10 n6 VSS VSS sg13_lv_nmos w=3e-07 l=1.3e-07 ng=1
MP8 n9 n0 n11 VDD sg13_lv_pmos w=4.5e-07 l=1.3e-07 ng=1
MP9 n11 n6 VDD VDD sg13_lv_pmos w=4.5e-07 l=1.3e-07 ng=1
MN10 n12 SN VSS VSS sg13_lv_nmos w=2e-07 l=1.3e-07 ng=1
MN11 n13 n9 n12 VSS sg13_lv_nmos w=2e-07 l=1.3e-07 ng=1
MP10 n13 SN VDD VDD sg13_lv_pmos w=2.2e-07 l=1.3e-07 ng=1
MP11 n13 n9 VDD VDD sg13_lv_pmos w=2.2e-07 l=1.3e-07 ng=1
MN12 n9 n0 n14 VSS sg13_lv_nmos w=1.5e-07 l=1.3e-07 ng=1
MN13 n14 n13 VSS VSS sg13_lv_nmos w=1.5e-07 l=1.3e-07 ng=1
MP12 n9 n1 n15 VDD sg13_lv_pmos w=1.5e-07 l=1.3e-07 ng=1
MP13 n15 n13 VDD VDD sg13_lv_pmos w=1.5e-07 l=1.3e-07 ng=1
MN14 n16 n13 VSS VSS sg13_lv_nmos w=2e-07 l=1.3e-07 ng=1
MP14 n16 n13 VDD VDD sg13_lv_pmos w=3e-07 l=1.3e-07 ng=1
MN15 Q n16 VSS VSS sg13_lv_nmos w=3.2e-07 l=1.3e-07 ng=1
MP15 Q n16 VDD VDD sg13_lv_pmos w=4.8e-07 l=1.3e-07 ng=1
.ENDS

****************************************
* Cell : DFEQN_D1
* Description : D flip-flop with enable and output QN.
* ┌───────┬─────┬─────┬──────┬────────────────┐
* │ CLK   │ D   │   E │ QN   │ Description    │
* ├───────┼─────┼─────┼──────┼────────────────┤
* │ R     │ 0   │   1 │ 1    │ Write 0        │
* ├───────┼─────┼─────┼──────┼────────────────┤
* │ R     │ 1   │   1 │ 0    │ Write 1        │
* ├───────┼─────┼─────┼──────┼────────────────┤
* │ R     │ -   │   0 │ QN   │ Write disabled │
* └───────┴─────┴─────┴──────┴────────────────┘
****************************************
.SUBCKT DFEQN_D1 D E CLK QN VDD VSS
*.PININFO CLK:I D:I E:I QN:O VDD:B VSS:B
MN0 n0 CLK VSS VSS sg13_lv_nmos w=3e-07 l=1.3e-07 ng=1
MP0 n0 CLK VDD VDD sg13_lv_pmos w=4.5e-07 l=1.3e-07 ng=1
MN1 n1 n0 VSS VSS sg13_lv_nmos w=1.5e-07 l=1.3e-07 ng=1
MP1 n1 n0 VDD VDD sg13_lv_pmos w=2.5e-07 l=1.3e-07 ng=1
MN2 n2 E VSS VSS sg13_lv_nmos w=1.5e-07 l=1.3e-07 ng=1
MP2 n2 E VDD VDD sg13_lv_pmos w=2.5e-07 l=1.3e-07 ng=1
MN3 n3 E VSS VSS sg13_lv_nmos w=1.5e-07 l=1.3e-07
MN4 n4 D n3 VSS sg13_lv_nmos w=1.5e-07 l=1.3e-07
MN5 n5 n2 VSS VSS sg13_lv_nmos w=1.5e-07 l=1.3e-07
MN6 n4 n6 n5 VSS sg13_lv_nmos w=1.5e-07 l=1.3e-07
MN7 n7 n0 n4 VSS sg13_lv_nmos w=1.5e-07 l=1.3e-07
MP3 n8 E VDD VDD sg13_lv_pmos w=2e-07 l=1.3e-07
MP4 n9 n6 n8 VDD sg13_lv_pmos w=2e-07 l=1.3e-07
MP5 n10 n2 VDD VDD sg13_lv_pmos w=2e-07 l=1.3e-07
MP6 n9 D n10 VDD sg13_lv_pmos w=2e-07 l=1.3e-07
MP7 n7 n1 n9 VDD sg13_lv_pmos w=2e-07 l=1.3e-07
MN8 n11 n7 VSS VSS sg13_lv_nmos w=2e-07 l=1.3e-07 ng=1
MP8 n11 n7 VDD VDD sg13_lv_pmos w=3e-07 l=1.3e-07 ng=1
MN9 n7 n1 n12 VSS sg13_lv_nmos w=1.5e-07 l=1.3e-07 ng=1
MN10 n12 n11 VSS VSS sg13_lv_nmos w=1.5e-07 l=1.3e-07 ng=1
MP9 n7 n0 n13 VDD sg13_lv_pmos w=2.5e-07 l=1.3e-07 ng=1
MP10 n13 n11 VDD VDD sg13_lv_pmos w=2.5e-07 l=1.3e-07 ng=1
MN11 n14 n1 n15 VSS sg13_lv_nmos w=6.2e-07 l=1.3e-07 ng=1
MN12 n15 n11 VSS VSS sg13_lv_nmos w=6.2e-07 l=1.3e-07 ng=1
MP11 n14 n0 n16 VDD sg13_lv_pmos w=9e-07 l=1.3e-07 ng=1
MP12 n16 n11 VDD VDD sg13_lv_pmos w=9e-07 l=1.3e-07 ng=1
MN13 n6 n14 VSS VSS sg13_lv_nmos w=2.5e-07 l=1.3e-07 ng=1
MP13 n6 n14 VDD VDD sg13_lv_pmos w=4.5e-07 l=1.3e-07 ng=1
MN14 n14 n0 n17 VSS sg13_lv_nmos w=1.5e-07 l=1.3e-07 ng=1
MN15 n17 n6 VSS VSS sg13_lv_nmos w=1.5e-07 l=1.3e-07 ng=1
MP14 n14 n1 n18 VDD sg13_lv_pmos w=1.5e-07 l=1.3e-07 ng=1
MP15 n18 n6 VDD VDD sg13_lv_pmos w=1.5e-07 l=1.3e-07 ng=1
MN16 QN n6 VSS VSS sg13_lv_nmos w=6.4e-07 l=1.3e-07 ng=1
MP16 QN n6 VDD VDD sg13_lv_pmos w=9.8e-07 l=1.3e-07 ng=1
.ENDS

****************************************
* Cell : DFEQN_D2
* Description : D flip-flop with enable and output QN.
* ┌───────┬─────┬─────┬──────┬────────────────┐
* │ CLK   │ D   │   E │ QN   │ Description    │
* ├───────┼─────┼─────┼──────┼────────────────┤
* │ R     │ 0   │   1 │ 1    │ Write 0        │
* ├───────┼─────┼─────┼──────┼────────────────┤
* │ R     │ 1   │   1 │ 0    │ Write 1        │
* ├───────┼─────┼─────┼──────┼────────────────┤
* │ R     │ -   │   0 │ QN   │ Write disabled │
* └───────┴─────┴─────┴──────┴────────────────┘
****************************************
.SUBCKT DFEQN_D2 D E CLK QN VDD VSS
*.PININFO CLK:I D:I E:I QN:O VDD:B VSS:B
MN0 n0 CLK VSS VSS sg13_lv_nmos w=6.4e-07 l=1.3e-07 ng=1
MP0 n0 CLK VDD VDD sg13_lv_pmos w=9.8e-07 l=1.3e-07 ng=1
MN1 n1 n0 VSS VSS sg13_lv_nmos w=3.2e-07 l=1.3e-07 ng=1
MP1 n1 n0 VDD VDD sg13_lv_pmos w=4.9e-07 l=1.3e-07 ng=1
MN2 n2 E VSS VSS sg13_lv_nmos w=1.5e-07 l=1.3e-07 ng=1
MP2 n2 E VDD VDD sg13_lv_pmos w=2.5e-07 l=1.3e-07 ng=1
MN3 n3 E VSS VSS sg13_lv_nmos w=2.5e-07 l=1.3e-07
MN4 n4 D n3 VSS sg13_lv_nmos w=2.5e-07 l=1.3e-07
MN5 n5 n2 VSS VSS sg13_lv_nmos w=2.5e-07 l=1.3e-07
MN6 n4 n6 n5 VSS sg13_lv_nmos w=2.5e-07 l=1.3e-07
MN7 n7 n0 n4 VSS sg13_lv_nmos w=2.5e-07 l=1.3e-07
MP3 n8 E VDD VDD sg13_lv_pmos w=4e-07 l=1.3e-07
MP4 n9 n6 n8 VDD sg13_lv_pmos w=4e-07 l=1.3e-07
MP5 n10 n2 VDD VDD sg13_lv_pmos w=4e-07 l=1.3e-07
MP6 n9 D n10 VDD sg13_lv_pmos w=4e-07 l=1.3e-07
MP7 n7 n1 n9 VDD sg13_lv_pmos w=4e-07 l=1.3e-07
MN8 n11 n7 VSS VSS sg13_lv_nmos w=4.5e-07 l=1.3e-07 ng=1
MP8 n11 n7 VDD VDD sg13_lv_pmos w=7e-07 l=1.3e-07 ng=1
MN9 n7 n1 n12 VSS sg13_lv_nmos w=1.5e-07 l=1.3e-07 ng=1
MN10 n12 n11 VSS VSS sg13_lv_nmos w=1.5e-07 l=1.3e-07 ng=1
MP9 n7 n0 n13 VDD sg13_lv_pmos w=2.5e-07 l=1.3e-07 ng=1
MP10 n13 n11 VDD VDD sg13_lv_pmos w=2.5e-07 l=1.3e-07 ng=1
MN11 n14 n1 n15 VSS sg13_lv_nmos w=6e-07 l=1.3e-07 ng=1
MN12 n15 n11 VSS VSS sg13_lv_nmos w=6e-07 l=1.3e-07 ng=1
MP11 n14 n0 n16 VDD sg13_lv_pmos w=9e-07 l=1.3e-07 ng=1
MP12 n16 n11 VDD VDD sg13_lv_pmos w=9e-07 l=1.3e-07 ng=1
MN13 n14 n1 n17 VSS sg13_lv_nmos w=6e-07 l=1.3e-07 ng=1
MN14 n17 n11 VSS VSS sg13_lv_nmos w=6e-07 l=1.3e-07 ng=1
MP13 n14 n0 n18 VDD sg13_lv_pmos w=9e-07 l=1.3e-07 ng=1
MP14 n18 n11 VDD VDD sg13_lv_pmos w=9e-07 l=1.3e-07 ng=1
MN15 n6 n14 VSS VSS sg13_lv_nmos w=6.5e-07 l=1.3e-07 ng=1
MP15 n6 n14 VDD VDD sg13_lv_pmos w=9e-07 l=1.3e-07 ng=1
MN16 n14 n0 n19 VSS sg13_lv_nmos w=1.5e-07 l=1.3e-07 ng=1
MN17 n19 n6 VSS VSS sg13_lv_nmos w=1.5e-07 l=1.3e-07 ng=1
MP16 n14 n1 n20 VDD sg13_lv_pmos w=1.5e-07 l=1.3e-07 ng=1
MP17 n20 n6 VDD VDD sg13_lv_pmos w=1.5e-07 l=1.3e-07 ng=1
MN18 QN n6 VSS VSS sg13_lv_nmos w=1.07e-06 l=1.3e-07 ng=1
MP18 QN n6 VDD VDD sg13_lv_pmos w=1.6e-06 l=1.3e-07 ng=1
.ENDS

****************************************
* Cell : DFEQN_DL
* Description : D flip-flop with enable and output QN.
* ┌───────┬─────┬─────┬──────┬────────────────┐
* │ CLK   │ D   │   E │ QN   │ Description    │
* ├───────┼─────┼─────┼──────┼────────────────┤
* │ R     │ 0   │   1 │ 1    │ Write 0        │
* ├───────┼─────┼─────┼──────┼────────────────┤
* │ R     │ 1   │   1 │ 0    │ Write 1        │
* ├───────┼─────┼─────┼──────┼────────────────┤
* │ R     │ -   │   0 │ QN   │ Write disabled │
* └───────┴─────┴─────┴──────┴────────────────┘
****************************************
.SUBCKT DFEQN_DL D E CLK QN VDD VSS
*.PININFO CLK:I D:I E:I QN:O VDD:B VSS:B
MN0 n0 CLK VSS VSS sg13_lv_nmos w=2e-07 l=1.3e-07 ng=1
MP0 n0 CLK VDD VDD sg13_lv_pmos w=3e-07 l=1.3e-07 ng=1
MN1 n1 n0 VSS VSS sg13_lv_nmos w=1.5e-07 l=1.3e-07 ng=1
MP1 n1 n0 VDD VDD sg13_lv_pmos w=2.5e-07 l=1.3e-07 ng=1
MN2 n2 E VSS VSS sg13_lv_nmos w=1.5e-07 l=1.3e-07 ng=1
MP2 n2 E VDD VDD sg13_lv_pmos w=2.5e-07 l=1.3e-07 ng=1
MN3 n3 E VSS VSS sg13_lv_nmos w=1.5e-07 l=1.3e-07
MN4 n4 D n3 VSS sg13_lv_nmos w=1.5e-07 l=1.3e-07
MN5 n5 n2 VSS VSS sg13_lv_nmos w=1.5e-07 l=1.3e-07
MN6 n4 n6 n5 VSS sg13_lv_nmos w=1.5e-07 l=1.3e-07
MN7 n7 n0 n4 VSS sg13_lv_nmos w=1.5e-07 l=1.3e-07
MP3 n8 E VDD VDD sg13_lv_pmos w=2e-07 l=1.3e-07
MP4 n9 n6 n8 VDD sg13_lv_pmos w=2e-07 l=1.3e-07
MP5 n10 n2 VDD VDD sg13_lv_pmos w=2e-07 l=1.3e-07
MP6 n9 D n10 VDD sg13_lv_pmos w=2e-07 l=1.3e-07
MP7 n7 n1 n9 VDD sg13_lv_pmos w=2e-07 l=1.3e-07
MN8 n11 n7 VSS VSS sg13_lv_nmos w=2e-07 l=1.3e-07 ng=1
MP8 n11 n7 VDD VDD sg13_lv_pmos w=3e-07 l=1.3e-07 ng=1
MN9 n7 n1 n12 VSS sg13_lv_nmos w=1.5e-07 l=1.3e-07 ng=1
MN10 n12 n11 VSS VSS sg13_lv_nmos w=1.5e-07 l=1.3e-07 ng=1
MP9 n7 n0 n13 VDD sg13_lv_pmos w=2.5e-07 l=1.3e-07 ng=1
MP10 n13 n11 VDD VDD sg13_lv_pmos w=2.5e-07 l=1.3e-07 ng=1
MN11 n14 n1 n15 VSS sg13_lv_nmos w=4e-07 l=1.3e-07 ng=1
MN12 n15 n11 VSS VSS sg13_lv_nmos w=4e-07 l=1.3e-07 ng=1
MP11 n14 n0 n16 VDD sg13_lv_pmos w=6e-07 l=1.3e-07 ng=1
MP12 n16 n11 VDD VDD sg13_lv_pmos w=6e-07 l=1.3e-07 ng=1
MN13 n6 n14 VSS VSS sg13_lv_nmos w=2e-07 l=1.3e-07 ng=1
MP13 n6 n14 VDD VDD sg13_lv_pmos w=3e-07 l=1.3e-07 ng=1
MN14 n14 n0 n17 VSS sg13_lv_nmos w=1.5e-07 l=1.3e-07 ng=1
MN15 n17 n6 VSS VSS sg13_lv_nmos w=1.5e-07 l=1.3e-07 ng=1
MP14 n14 n1 n18 VDD sg13_lv_pmos w=1.5e-07 l=1.3e-07 ng=1
MP15 n18 n6 VDD VDD sg13_lv_pmos w=1.5e-07 l=1.3e-07 ng=1
MN16 QN n6 VSS VSS sg13_lv_nmos w=3.2e-07 l=1.3e-07 ng=1
MP16 QN n6 VDD VDD sg13_lv_pmos w=4.9e-07 l=1.3e-07 ng=1
.ENDS

****************************************
* Cell : DFEQQN_D1
* Description : D flip-flop with enable and outputs Q and QN.
* ┌───────┬─────┬─────┬─────┬──────┬────────────────┐
* │ CLK   │ D   │   E │ Q   │ QN   │ Description    │
* ├───────┼─────┼─────┼─────┼──────┼────────────────┤
* │ R     │ 0   │   1 │ 0   │ 1    │ Write 0        │
* ├───────┼─────┼─────┼─────┼──────┼────────────────┤
* │ R     │ 1   │   1 │ 1   │ 0    │ Write 1        │
* ├───────┼─────┼─────┼─────┼──────┼────────────────┤
* │ R     │ -   │   0 │ Q   │ QN   │ Write disabled │
* └───────┴─────┴─────┴─────┴──────┴────────────────┘
****************************************
.SUBCKT DFEQQN_D1 D E CLK Q QN VDD VSS
*.PININFO CLK:I D:I E:I Q:O QN:O VDD:B VSS:B
MN0 n0 CLK VSS VSS sg13_lv_nmos w=3e-07 l=1.3e-07 ng=1
MP0 n0 CLK VDD VDD sg13_lv_pmos w=4.5e-07 l=1.3e-07 ng=1
MN1 n1 n0 VSS VSS sg13_lv_nmos w=1.5e-07 l=1.3e-07 ng=1
MP1 n1 n0 VDD VDD sg13_lv_pmos w=2.5e-07 l=1.3e-07 ng=1
MN2 n2 E VSS VSS sg13_lv_nmos w=1.5e-07 l=1.3e-07 ng=1
MP2 n2 E VDD VDD sg13_lv_pmos w=2.5e-07 l=1.3e-07 ng=1
MN3 n3 E VSS VSS sg13_lv_nmos w=1.5e-07 l=1.3e-07
MN4 n4 D n3 VSS sg13_lv_nmos w=1.5e-07 l=1.3e-07
MN5 n5 n2 VSS VSS sg13_lv_nmos w=1.5e-07 l=1.3e-07
MN6 n4 n6 n5 VSS sg13_lv_nmos w=1.5e-07 l=1.3e-07
MN7 n7 n0 n4 VSS sg13_lv_nmos w=1.5e-07 l=1.3e-07
MP3 n8 E VDD VDD sg13_lv_pmos w=2e-07 l=1.3e-07
MP4 n9 n6 n8 VDD sg13_lv_pmos w=2e-07 l=1.3e-07
MP5 n10 n2 VDD VDD sg13_lv_pmos w=2e-07 l=1.3e-07
MP6 n9 D n10 VDD sg13_lv_pmos w=2e-07 l=1.3e-07
MP7 n7 n1 n9 VDD sg13_lv_pmos w=2e-07 l=1.3e-07
MN8 n11 n7 VSS VSS sg13_lv_nmos w=2e-07 l=1.3e-07 ng=1
MP8 n11 n7 VDD VDD sg13_lv_pmos w=3e-07 l=1.3e-07 ng=1
MN9 n7 n1 n12 VSS sg13_lv_nmos w=1.5e-07 l=1.3e-07 ng=1
MN10 n12 n11 VSS VSS sg13_lv_nmos w=1.5e-07 l=1.3e-07 ng=1
MP9 n7 n0 n13 VDD sg13_lv_pmos w=2.5e-07 l=1.3e-07 ng=1
MP10 n13 n11 VDD VDD sg13_lv_pmos w=2.5e-07 l=1.3e-07 ng=1
MN11 n14 n1 n15 VSS sg13_lv_nmos w=6.2e-07 l=1.3e-07 ng=1
MN12 n15 n11 VSS VSS sg13_lv_nmos w=6.2e-07 l=1.3e-07 ng=1
MP11 n14 n0 n16 VDD sg13_lv_pmos w=9e-07 l=1.3e-07 ng=1
MP12 n16 n11 VDD VDD sg13_lv_pmos w=9e-07 l=1.3e-07 ng=1
MN13 n6 n14 VSS VSS sg13_lv_nmos w=2.5e-07 l=1.3e-07 ng=1
MP13 n6 n14 VDD VDD sg13_lv_pmos w=4.5e-07 l=1.3e-07 ng=1
MN14 n14 n0 n17 VSS sg13_lv_nmos w=1.5e-07 l=1.3e-07 ng=1
MN15 n17 n6 VSS VSS sg13_lv_nmos w=1.5e-07 l=1.3e-07 ng=1
MP14 n14 n1 n18 VDD sg13_lv_pmos w=1.5e-07 l=1.3e-07 ng=1
MP15 n18 n6 VDD VDD sg13_lv_pmos w=1.5e-07 l=1.3e-07 ng=1
MN16 Q n14 VSS VSS sg13_lv_nmos w=6.4e-07 l=1.3e-07 ng=1
MP16 Q n14 VDD VDD sg13_lv_pmos w=9.8e-07 l=1.3e-07 ng=1
MN17 QN n6 VSS VSS sg13_lv_nmos w=6.4e-07 l=1.3e-07 ng=1
MP17 QN n6 VDD VDD sg13_lv_pmos w=9.8e-07 l=1.3e-07 ng=1
.ENDS

****************************************
* Cell : DFEQQN_D2
* Description : D flip-flop with enable and outputs Q and QN.
* ┌───────┬─────┬─────┬─────┬──────┬────────────────┐
* │ CLK   │ D   │   E │ Q   │ QN   │ Description    │
* ├───────┼─────┼─────┼─────┼──────┼────────────────┤
* │ R     │ 0   │   1 │ 0   │ 1    │ Write 0        │
* ├───────┼─────┼─────┼─────┼──────┼────────────────┤
* │ R     │ 1   │   1 │ 1   │ 0    │ Write 1        │
* ├───────┼─────┼─────┼─────┼──────┼────────────────┤
* │ R     │ -   │   0 │ Q   │ QN   │ Write disabled │
* └───────┴─────┴─────┴─────┴──────┴────────────────┘
****************************************
.SUBCKT DFEQQN_D2 D E CLK Q QN VDD VSS
*.PININFO CLK:I D:I E:I Q:O QN:O VDD:B VSS:B
MN0 n0 CLK VSS VSS sg13_lv_nmos w=6.4e-07 l=1.3e-07 ng=1
MP0 n0 CLK VDD VDD sg13_lv_pmos w=9.8e-07 l=1.3e-07 ng=1
MN1 n1 n0 VSS VSS sg13_lv_nmos w=3.2e-07 l=1.3e-07 ng=1
MP1 n1 n0 VDD VDD sg13_lv_pmos w=4.9e-07 l=1.3e-07 ng=1
MN2 n2 E VSS VSS sg13_lv_nmos w=1.5e-07 l=1.3e-07 ng=1
MP2 n2 E VDD VDD sg13_lv_pmos w=2.5e-07 l=1.3e-07 ng=1
MN3 n3 E VSS VSS sg13_lv_nmos w=2.5e-07 l=1.3e-07
MN4 n4 D n3 VSS sg13_lv_nmos w=2.5e-07 l=1.3e-07
MN5 n5 n2 VSS VSS sg13_lv_nmos w=2.5e-07 l=1.3e-07
MN6 n4 n6 n5 VSS sg13_lv_nmos w=2.5e-07 l=1.3e-07
MN7 n7 n0 n4 VSS sg13_lv_nmos w=2.5e-07 l=1.3e-07
MP3 n8 E VDD VDD sg13_lv_pmos w=4e-07 l=1.3e-07
MP4 n9 n6 n8 VDD sg13_lv_pmos w=4e-07 l=1.3e-07
MP5 n10 n2 VDD VDD sg13_lv_pmos w=4e-07 l=1.3e-07
MP6 n9 D n10 VDD sg13_lv_pmos w=4e-07 l=1.3e-07
MP7 n7 n1 n9 VDD sg13_lv_pmos w=4e-07 l=1.3e-07
MN8 n11 n7 VSS VSS sg13_lv_nmos w=4.5e-07 l=1.3e-07 ng=1
MP8 n11 n7 VDD VDD sg13_lv_pmos w=7e-07 l=1.3e-07 ng=1
MN9 n7 n1 n12 VSS sg13_lv_nmos w=1.5e-07 l=1.3e-07 ng=1
MN10 n12 n11 VSS VSS sg13_lv_nmos w=1.5e-07 l=1.3e-07 ng=1
MP9 n7 n0 n13 VDD sg13_lv_pmos w=2.5e-07 l=1.3e-07 ng=1
MP10 n13 n11 VDD VDD sg13_lv_pmos w=2.5e-07 l=1.3e-07 ng=1
MN11 n14 n1 n15 VSS sg13_lv_nmos w=6e-07 l=1.3e-07 ng=1
MN12 n15 n11 VSS VSS sg13_lv_nmos w=6e-07 l=1.3e-07 ng=1
MP11 n14 n0 n16 VDD sg13_lv_pmos w=9e-07 l=1.3e-07 ng=1
MP12 n16 n11 VDD VDD sg13_lv_pmos w=9e-07 l=1.3e-07 ng=1
MN13 n14 n1 n17 VSS sg13_lv_nmos w=6e-07 l=1.3e-07 ng=1
MN14 n17 n11 VSS VSS sg13_lv_nmos w=6e-07 l=1.3e-07 ng=1
MP13 n14 n0 n18 VDD sg13_lv_pmos w=9e-07 l=1.3e-07 ng=1
MP14 n18 n11 VDD VDD sg13_lv_pmos w=9e-07 l=1.3e-07 ng=1
MN15 n6 n14 VSS VSS sg13_lv_nmos w=6.5e-07 l=1.3e-07 ng=1
MP15 n6 n14 VDD VDD sg13_lv_pmos w=9e-07 l=1.3e-07 ng=1
MN16 n14 n0 n19 VSS sg13_lv_nmos w=1.5e-07 l=1.3e-07 ng=1
MN17 n19 n6 VSS VSS sg13_lv_nmos w=1.5e-07 l=1.3e-07 ng=1
MP16 n14 n1 n20 VDD sg13_lv_pmos w=1.5e-07 l=1.3e-07 ng=1
MP17 n20 n6 VDD VDD sg13_lv_pmos w=1.5e-07 l=1.3e-07 ng=1
MN18 Q n14 VSS VSS sg13_lv_nmos w=1.07e-06 l=1.3e-07 ng=1
MP18 Q n14 VDD VDD sg13_lv_pmos w=1.6e-06 l=1.3e-07 ng=1
MN19 QN n6 VSS VSS sg13_lv_nmos w=1.07e-06 l=1.3e-07 ng=1
MP19 QN n6 VDD VDD sg13_lv_pmos w=1.6e-06 l=1.3e-07 ng=1
.ENDS

****************************************
* Cell : DFEQQN_DL
* Description : D flip-flop with enable and outputs Q and QN.
* ┌───────┬─────┬─────┬─────┬──────┬────────────────┐
* │ CLK   │ D   │   E │ Q   │ QN   │ Description    │
* ├───────┼─────┼─────┼─────┼──────┼────────────────┤
* │ R     │ 0   │   1 │ 0   │ 1    │ Write 0        │
* ├───────┼─────┼─────┼─────┼──────┼────────────────┤
* │ R     │ 1   │   1 │ 1   │ 0    │ Write 1        │
* ├───────┼─────┼─────┼─────┼──────┼────────────────┤
* │ R     │ -   │   0 │ Q   │ QN   │ Write disabled │
* └───────┴─────┴─────┴─────┴──────┴────────────────┘
****************************************
.SUBCKT DFEQQN_DL D E CLK Q QN VDD VSS
*.PININFO CLK:I D:I E:I Q:O QN:O VDD:B VSS:B
MN0 n0 CLK VSS VSS sg13_lv_nmos w=2e-07 l=1.3e-07 ng=1
MP0 n0 CLK VDD VDD sg13_lv_pmos w=3e-07 l=1.3e-07 ng=1
MN1 n1 n0 VSS VSS sg13_lv_nmos w=1.5e-07 l=1.3e-07 ng=1
MP1 n1 n0 VDD VDD sg13_lv_pmos w=2.5e-07 l=1.3e-07 ng=1
MN2 n2 E VSS VSS sg13_lv_nmos w=1.5e-07 l=1.3e-07 ng=1
MP2 n2 E VDD VDD sg13_lv_pmos w=2.5e-07 l=1.3e-07 ng=1
MN3 n3 E VSS VSS sg13_lv_nmos w=1.5e-07 l=1.3e-07
MN4 n4 D n3 VSS sg13_lv_nmos w=1.5e-07 l=1.3e-07
MN5 n5 n2 VSS VSS sg13_lv_nmos w=1.5e-07 l=1.3e-07
MN6 n4 n6 n5 VSS sg13_lv_nmos w=1.5e-07 l=1.3e-07
MN7 n7 n0 n4 VSS sg13_lv_nmos w=1.5e-07 l=1.3e-07
MP3 n8 E VDD VDD sg13_lv_pmos w=2e-07 l=1.3e-07
MP4 n9 n6 n8 VDD sg13_lv_pmos w=2e-07 l=1.3e-07
MP5 n10 n2 VDD VDD sg13_lv_pmos w=2e-07 l=1.3e-07
MP6 n9 D n10 VDD sg13_lv_pmos w=2e-07 l=1.3e-07
MP7 n7 n1 n9 VDD sg13_lv_pmos w=2e-07 l=1.3e-07
MN8 n11 n7 VSS VSS sg13_lv_nmos w=2e-07 l=1.3e-07 ng=1
MP8 n11 n7 VDD VDD sg13_lv_pmos w=3e-07 l=1.3e-07 ng=1
MN9 n7 n1 n12 VSS sg13_lv_nmos w=1.5e-07 l=1.3e-07 ng=1
MN10 n12 n11 VSS VSS sg13_lv_nmos w=1.5e-07 l=1.3e-07 ng=1
MP9 n7 n0 n13 VDD sg13_lv_pmos w=2.5e-07 l=1.3e-07 ng=1
MP10 n13 n11 VDD VDD sg13_lv_pmos w=2.5e-07 l=1.3e-07 ng=1
MN11 n14 n1 n15 VSS sg13_lv_nmos w=4e-07 l=1.3e-07 ng=1
MN12 n15 n11 VSS VSS sg13_lv_nmos w=4e-07 l=1.3e-07 ng=1
MP11 n14 n0 n16 VDD sg13_lv_pmos w=6e-07 l=1.3e-07 ng=1
MP12 n16 n11 VDD VDD sg13_lv_pmos w=6e-07 l=1.3e-07 ng=1
MN13 n6 n14 VSS VSS sg13_lv_nmos w=2e-07 l=1.3e-07 ng=1
MP13 n6 n14 VDD VDD sg13_lv_pmos w=3e-07 l=1.3e-07 ng=1
MN14 n14 n0 n17 VSS sg13_lv_nmos w=1.5e-07 l=1.3e-07 ng=1
MN15 n17 n6 VSS VSS sg13_lv_nmos w=1.5e-07 l=1.3e-07 ng=1
MP14 n14 n1 n18 VDD sg13_lv_pmos w=1.5e-07 l=1.3e-07 ng=1
MP15 n18 n6 VDD VDD sg13_lv_pmos w=1.5e-07 l=1.3e-07 ng=1
MN16 Q n14 VSS VSS sg13_lv_nmos w=3.2e-07 l=1.3e-07 ng=1
MP16 Q n14 VDD VDD sg13_lv_pmos w=4.9e-07 l=1.3e-07 ng=1
MN17 QN n6 VSS VSS sg13_lv_nmos w=3.2e-07 l=1.3e-07 ng=1
MP17 QN n6 VDD VDD sg13_lv_pmos w=4.9e-07 l=1.3e-07 ng=1
.ENDS

****************************************
* Cell : DFEQ_D1
* Description : D flip-flop with enable and output Q.
* ┌───────┬─────┬─────┬─────┬────────────────┐
* │ CLK   │ D   │   E │ Q   │ Description    │
* ├───────┼─────┼─────┼─────┼────────────────┤
* │ R     │ 0   │   1 │ 0   │ Write 0        │
* ├───────┼─────┼─────┼─────┼────────────────┤
* │ R     │ 1   │   1 │ 1   │ Write 1        │
* ├───────┼─────┼─────┼─────┼────────────────┤
* │ R     │ -   │   0 │ Q   │ Write disabled │
* └───────┴─────┴─────┴─────┴────────────────┘
****************************************
.SUBCKT DFEQ_D1 D E CLK Q VDD VSS
*.PININFO CLK:I D:I E:I Q:O VDD:B VSS:B
MN0 n0 CLK VSS VSS sg13_lv_nmos w=3e-07 l=1.3e-07 ng=1
MP0 n0 CLK VDD VDD sg13_lv_pmos w=4.5e-07 l=1.3e-07 ng=1
MN1 n1 n0 VSS VSS sg13_lv_nmos w=1.5e-07 l=1.3e-07 ng=1
MP1 n1 n0 VDD VDD sg13_lv_pmos w=2.5e-07 l=1.3e-07 ng=1
MN2 n2 E VSS VSS sg13_lv_nmos w=1.5e-07 l=1.3e-07 ng=1
MP2 n2 E VDD VDD sg13_lv_pmos w=2.5e-07 l=1.3e-07 ng=1
MN3 n3 E VSS VSS sg13_lv_nmos w=1.5e-07 l=1.3e-07
MN4 n4 D n3 VSS sg13_lv_nmos w=1.5e-07 l=1.3e-07
MN5 n5 n2 VSS VSS sg13_lv_nmos w=1.5e-07 l=1.3e-07
MN6 n4 n6 n5 VSS sg13_lv_nmos w=1.5e-07 l=1.3e-07
MN7 n7 n0 n4 VSS sg13_lv_nmos w=1.5e-07 l=1.3e-07
MP3 n8 E VDD VDD sg13_lv_pmos w=2e-07 l=1.3e-07
MP4 n9 n6 n8 VDD sg13_lv_pmos w=2e-07 l=1.3e-07
MP5 n10 n2 VDD VDD sg13_lv_pmos w=2e-07 l=1.3e-07
MP6 n9 D n10 VDD sg13_lv_pmos w=2e-07 l=1.3e-07
MP7 n7 n1 n9 VDD sg13_lv_pmos w=2e-07 l=1.3e-07
MN8 n11 n7 VSS VSS sg13_lv_nmos w=2e-07 l=1.3e-07 ng=1
MP8 n11 n7 VDD VDD sg13_lv_pmos w=3e-07 l=1.3e-07 ng=1
MN9 n7 n1 n12 VSS sg13_lv_nmos w=1.5e-07 l=1.3e-07 ng=1
MN10 n12 n11 VSS VSS sg13_lv_nmos w=1.5e-07 l=1.3e-07 ng=1
MP9 n7 n0 n13 VDD sg13_lv_pmos w=2.5e-07 l=1.3e-07 ng=1
MP10 n13 n11 VDD VDD sg13_lv_pmos w=2.5e-07 l=1.3e-07 ng=1
MN11 n14 n1 n15 VSS sg13_lv_nmos w=6.2e-07 l=1.3e-07 ng=1
MN12 n15 n11 VSS VSS sg13_lv_nmos w=6.2e-07 l=1.3e-07 ng=1
MP11 n14 n0 n16 VDD sg13_lv_pmos w=9e-07 l=1.3e-07 ng=1
MP12 n16 n11 VDD VDD sg13_lv_pmos w=9e-07 l=1.3e-07 ng=1
MN13 n6 n14 VSS VSS sg13_lv_nmos w=2.5e-07 l=1.3e-07 ng=1
MP13 n6 n14 VDD VDD sg13_lv_pmos w=4.5e-07 l=1.3e-07 ng=1
MN14 n14 n0 n17 VSS sg13_lv_nmos w=1.5e-07 l=1.3e-07 ng=1
MN15 n17 n6 VSS VSS sg13_lv_nmos w=1.5e-07 l=1.3e-07 ng=1
MP14 n14 n1 n18 VDD sg13_lv_pmos w=1.5e-07 l=1.3e-07 ng=1
MP15 n18 n6 VDD VDD sg13_lv_pmos w=1.5e-07 l=1.3e-07 ng=1
MN16 Q n14 VSS VSS sg13_lv_nmos w=6.4e-07 l=1.3e-07 ng=1
MP16 Q n14 VDD VDD sg13_lv_pmos w=9.8e-07 l=1.3e-07 ng=1
.ENDS

****************************************
* Cell : DFEQ_D2
* Description : D flip-flop with enable and output Q.
* ┌───────┬─────┬─────┬─────┬────────────────┐
* │ CLK   │ D   │   E │ Q   │ Description    │
* ├───────┼─────┼─────┼─────┼────────────────┤
* │ R     │ 0   │   1 │ 0   │ Write 0        │
* ├───────┼─────┼─────┼─────┼────────────────┤
* │ R     │ 1   │   1 │ 1   │ Write 1        │
* ├───────┼─────┼─────┼─────┼────────────────┤
* │ R     │ -   │   0 │ Q   │ Write disabled │
* └───────┴─────┴─────┴─────┴────────────────┘
****************************************
.SUBCKT DFEQ_D2 D E CLK Q VDD VSS
*.PININFO CLK:I D:I E:I Q:O VDD:B VSS:B
MN0 n0 CLK VSS VSS sg13_lv_nmos w=6.4e-07 l=1.3e-07 ng=1
MP0 n0 CLK VDD VDD sg13_lv_pmos w=9.8e-07 l=1.3e-07 ng=1
MN1 n1 n0 VSS VSS sg13_lv_nmos w=3.2e-07 l=1.3e-07 ng=1
MP1 n1 n0 VDD VDD sg13_lv_pmos w=4.9e-07 l=1.3e-07 ng=1
MN2 n2 E VSS VSS sg13_lv_nmos w=1.5e-07 l=1.3e-07 ng=1
MP2 n2 E VDD VDD sg13_lv_pmos w=2.5e-07 l=1.3e-07 ng=1
MN3 n3 E VSS VSS sg13_lv_nmos w=2.5e-07 l=1.3e-07
MN4 n4 D n3 VSS sg13_lv_nmos w=2.5e-07 l=1.3e-07
MN5 n5 n2 VSS VSS sg13_lv_nmos w=2.5e-07 l=1.3e-07
MN6 n4 n6 n5 VSS sg13_lv_nmos w=2.5e-07 l=1.3e-07
MN7 n7 n0 n4 VSS sg13_lv_nmos w=2.5e-07 l=1.3e-07
MP3 n8 E VDD VDD sg13_lv_pmos w=4e-07 l=1.3e-07
MP4 n9 n6 n8 VDD sg13_lv_pmos w=4e-07 l=1.3e-07
MP5 n10 n2 VDD VDD sg13_lv_pmos w=4e-07 l=1.3e-07
MP6 n9 D n10 VDD sg13_lv_pmos w=4e-07 l=1.3e-07
MP7 n7 n1 n9 VDD sg13_lv_pmos w=4e-07 l=1.3e-07
MN8 n11 n7 VSS VSS sg13_lv_nmos w=4.5e-07 l=1.3e-07 ng=1
MP8 n11 n7 VDD VDD sg13_lv_pmos w=7e-07 l=1.3e-07 ng=1
MN9 n7 n1 n12 VSS sg13_lv_nmos w=1.5e-07 l=1.3e-07 ng=1
MN10 n12 n11 VSS VSS sg13_lv_nmos w=1.5e-07 l=1.3e-07 ng=1
MP9 n7 n0 n13 VDD sg13_lv_pmos w=2.5e-07 l=1.3e-07 ng=1
MP10 n13 n11 VDD VDD sg13_lv_pmos w=2.5e-07 l=1.3e-07 ng=1
MN11 n14 n1 n15 VSS sg13_lv_nmos w=6e-07 l=1.3e-07 ng=1
MN12 n15 n11 VSS VSS sg13_lv_nmos w=6e-07 l=1.3e-07 ng=1
MP11 n14 n0 n16 VDD sg13_lv_pmos w=9e-07 l=1.3e-07 ng=1
MP12 n16 n11 VDD VDD sg13_lv_pmos w=9e-07 l=1.3e-07 ng=1
MN13 n14 n1 n17 VSS sg13_lv_nmos w=6e-07 l=1.3e-07 ng=1
MN14 n17 n11 VSS VSS sg13_lv_nmos w=6e-07 l=1.3e-07 ng=1
MP13 n14 n0 n18 VDD sg13_lv_pmos w=9e-07 l=1.3e-07 ng=1
MP14 n18 n11 VDD VDD sg13_lv_pmos w=9e-07 l=1.3e-07 ng=1
MN15 n6 n14 VSS VSS sg13_lv_nmos w=6.5e-07 l=1.3e-07 ng=1
MP15 n6 n14 VDD VDD sg13_lv_pmos w=9e-07 l=1.3e-07 ng=1
MN16 n14 n0 n19 VSS sg13_lv_nmos w=1.5e-07 l=1.3e-07 ng=1
MN17 n19 n6 VSS VSS sg13_lv_nmos w=1.5e-07 l=1.3e-07 ng=1
MP16 n14 n1 n20 VDD sg13_lv_pmos w=1.5e-07 l=1.3e-07 ng=1
MP17 n20 n6 VDD VDD sg13_lv_pmos w=1.5e-07 l=1.3e-07 ng=1
MN18 Q n14 VSS VSS sg13_lv_nmos w=1.07e-06 l=1.3e-07 ng=1
MP18 Q n14 VDD VDD sg13_lv_pmos w=1.6e-06 l=1.3e-07 ng=1
.ENDS

****************************************
* Cell : DFEQ_DL
* Description : D flip-flop with enable and output Q.
* ┌───────┬─────┬─────┬─────┬────────────────┐
* │ CLK   │ D   │   E │ Q   │ Description    │
* ├───────┼─────┼─────┼─────┼────────────────┤
* │ R     │ 0   │   1 │ 0   │ Write 0        │
* ├───────┼─────┼─────┼─────┼────────────────┤
* │ R     │ 1   │   1 │ 1   │ Write 1        │
* ├───────┼─────┼─────┼─────┼────────────────┤
* │ R     │ -   │   0 │ Q   │ Write disabled │
* └───────┴─────┴─────┴─────┴────────────────┘
****************************************
.SUBCKT DFEQ_DL D E CLK Q VDD VSS
*.PININFO CLK:I D:I E:I Q:O VDD:B VSS:B
MN0 n0 CLK VSS VSS sg13_lv_nmos w=2e-07 l=1.3e-07 ng=1
MP0 n0 CLK VDD VDD sg13_lv_pmos w=3e-07 l=1.3e-07 ng=1
MN1 n1 n0 VSS VSS sg13_lv_nmos w=1.5e-07 l=1.3e-07 ng=1
MP1 n1 n0 VDD VDD sg13_lv_pmos w=2.5e-07 l=1.3e-07 ng=1
MN2 n2 E VSS VSS sg13_lv_nmos w=1.5e-07 l=1.3e-07 ng=1
MP2 n2 E VDD VDD sg13_lv_pmos w=2.5e-07 l=1.3e-07 ng=1
MN3 n3 E VSS VSS sg13_lv_nmos w=1.5e-07 l=1.3e-07
MN4 n4 D n3 VSS sg13_lv_nmos w=1.5e-07 l=1.3e-07
MN5 n5 n2 VSS VSS sg13_lv_nmos w=1.5e-07 l=1.3e-07
MN6 n4 n6 n5 VSS sg13_lv_nmos w=1.5e-07 l=1.3e-07
MN7 n7 n0 n4 VSS sg13_lv_nmos w=1.5e-07 l=1.3e-07
MP3 n8 E VDD VDD sg13_lv_pmos w=2e-07 l=1.3e-07
MP4 n9 n6 n8 VDD sg13_lv_pmos w=2e-07 l=1.3e-07
MP5 n10 n2 VDD VDD sg13_lv_pmos w=2e-07 l=1.3e-07
MP6 n9 D n10 VDD sg13_lv_pmos w=2e-07 l=1.3e-07
MP7 n7 n1 n9 VDD sg13_lv_pmos w=2e-07 l=1.3e-07
MN8 n11 n7 VSS VSS sg13_lv_nmos w=2e-07 l=1.3e-07 ng=1
MP8 n11 n7 VDD VDD sg13_lv_pmos w=3e-07 l=1.3e-07 ng=1
MN9 n7 n1 n12 VSS sg13_lv_nmos w=1.5e-07 l=1.3e-07 ng=1
MN10 n12 n11 VSS VSS sg13_lv_nmos w=1.5e-07 l=1.3e-07 ng=1
MP9 n7 n0 n13 VDD sg13_lv_pmos w=2.5e-07 l=1.3e-07 ng=1
MP10 n13 n11 VDD VDD sg13_lv_pmos w=2.5e-07 l=1.3e-07 ng=1
MN11 n14 n1 n15 VSS sg13_lv_nmos w=4e-07 l=1.3e-07 ng=1
MN12 n15 n11 VSS VSS sg13_lv_nmos w=4e-07 l=1.3e-07 ng=1
MP11 n14 n0 n16 VDD sg13_lv_pmos w=6e-07 l=1.3e-07 ng=1
MP12 n16 n11 VDD VDD sg13_lv_pmos w=6e-07 l=1.3e-07 ng=1
MN13 n6 n14 VSS VSS sg13_lv_nmos w=2e-07 l=1.3e-07 ng=1
MP13 n6 n14 VDD VDD sg13_lv_pmos w=3e-07 l=1.3e-07 ng=1
MN14 n14 n0 n17 VSS sg13_lv_nmos w=1.5e-07 l=1.3e-07 ng=1
MN15 n17 n6 VSS VSS sg13_lv_nmos w=1.5e-07 l=1.3e-07 ng=1
MP14 n14 n1 n18 VDD sg13_lv_pmos w=1.5e-07 l=1.3e-07 ng=1
MP15 n18 n6 VDD VDD sg13_lv_pmos w=1.5e-07 l=1.3e-07 ng=1
MN16 Q n14 VSS VSS sg13_lv_nmos w=3.2e-07 l=1.3e-07 ng=1
MP16 Q n14 VDD VDD sg13_lv_pmos w=4.9e-07 l=1.3e-07 ng=1
.ENDS

****************************************
* Cell : DFERQN_D1
* Description : D flip-flop with enable, synchronous reset and output QN.
* ┌───────┬─────┬─────┬──────┬──────┬────────────────┐
* │ CLK   │ D   │ E   │   RN │ QN   │ Description    │
* ├───────┼─────┼─────┼──────┼──────┼────────────────┤
* │ R     │ 0   │ 1   │    1 │ 1    │ Write 0        │
* ├───────┼─────┼─────┼──────┼──────┼────────────────┤
* │ R     │ 1   │ 1   │    1 │ 0    │ Write 1        │
* ├───────┼─────┼─────┼──────┼──────┼────────────────┤
* │ R     │ -   │ 0   │    1 │ QN   │ Write disabled │
* ├───────┼─────┼─────┼──────┼──────┼────────────────┤
* │ R     │ -   │ -   │    0 │ 1    │ Clear          │
* └───────┴─────┴─────┴──────┴──────┴────────────────┘
****************************************
.SUBCKT DFERQN_D1 D E RN CLK QN VDD VSS
*.PININFO CLK:I D:I E:I RN:I QN:O VDD:B VSS:B
MN0 n0 CLK VSS VSS sg13_lv_nmos w=3e-07 l=1.3e-07 ng=1
MP0 n0 CLK VDD VDD sg13_lv_pmos w=4.5e-07 l=1.3e-07 ng=1
MN1 n1 n0 VSS VSS sg13_lv_nmos w=1.5e-07 l=1.3e-07 ng=1
MP1 n1 n0 VDD VDD sg13_lv_pmos w=2.5e-07 l=1.3e-07 ng=1
MN2 n2 E VSS VSS sg13_lv_nmos w=1.5e-07 l=1.3e-07 ng=1
MP2 n2 E VDD VDD sg13_lv_pmos w=2.3e-07 l=1.3e-07 ng=1
MN3 n3 RN VSS VSS sg13_lv_nmos w=1.5e-07 l=1.3e-07
MN4 n4 E n3 VSS sg13_lv_nmos w=1.5e-07 l=1.3e-07
MN5 n5 D n4 VSS sg13_lv_nmos w=1.5e-07 l=1.3e-07
MN6 n6 n2 n3 VSS sg13_lv_nmos w=1.5e-07 l=1.3e-07
MN7 n5 n7 n6 VSS sg13_lv_nmos w=1.5e-07 l=1.3e-07
MN8 n8 n0 n5 VSS sg13_lv_nmos w=1.5e-07 l=1.3e-07
MP3 n9 RN VDD VDD sg13_lv_pmos w=2e-07 l=1.3e-07
MP4 n10 E VDD VDD sg13_lv_pmos w=2e-07 l=1.3e-07
MP5 n9 n7 n10 VDD sg13_lv_pmos w=2e-07 l=1.3e-07
MP6 n11 n2 VDD VDD sg13_lv_pmos w=2e-07 l=1.3e-07
MP7 n9 D n11 VDD sg13_lv_pmos w=2e-07 l=1.3e-07
MP8 n8 n1 n9 VDD sg13_lv_pmos w=2e-07 l=1.3e-07
MN9 n12 n8 VSS VSS sg13_lv_nmos w=2e-07 l=1.3e-07 ng=1
MP9 n12 n8 VDD VDD sg13_lv_pmos w=4e-07 l=1.3e-07 ng=1
MN10 n8 n1 n13 VSS sg13_lv_nmos w=1.5e-07 l=1.3e-07 ng=1
MN11 n13 n12 VSS VSS sg13_lv_nmos w=1.5e-07 l=1.3e-07 ng=1
MP10 n8 n0 n14 VDD sg13_lv_pmos w=3e-07 l=1.3e-07 ng=1
MP11 n14 n12 VDD VDD sg13_lv_pmos w=3e-07 l=1.3e-07 ng=1
MN12 n15 n1 n16 VSS sg13_lv_nmos w=6e-07 l=1.3e-07 ng=1
MN13 n16 n12 VSS VSS sg13_lv_nmos w=6e-07 l=1.3e-07 ng=1
MP12 n15 n0 n17 VDD sg13_lv_pmos w=9e-07 l=1.3e-07 ng=1
MP13 n17 n12 VDD VDD sg13_lv_pmos w=9e-07 l=1.3e-07 ng=1
MN14 n7 n15 VSS VSS sg13_lv_nmos w=3e-07 l=1.3e-07 ng=1
MP14 n7 n15 VDD VDD sg13_lv_pmos w=5e-07 l=1.3e-07 ng=1
MN15 n15 n0 n18 VSS sg13_lv_nmos w=1.5e-07 l=1.3e-07 ng=1
MN16 n18 n7 VSS VSS sg13_lv_nmos w=1.5e-07 l=1.3e-07 ng=1
MP15 n15 n1 n19 VDD sg13_lv_pmos w=1.5e-07 l=1.3e-07 ng=1
MP16 n19 n7 VDD VDD sg13_lv_pmos w=1.5e-07 l=1.3e-07 ng=1
MN17 QN n7 VSS VSS sg13_lv_nmos w=6.4e-07 l=1.3e-07 ng=1
MP17 QN n7 VDD VDD sg13_lv_pmos w=9.8e-07 l=1.3e-07 ng=1
.ENDS

****************************************
* Cell : DFERQN_D2
* Description : D flip-flop with enable, synchronous reset and output QN.
* ┌───────┬─────┬─────┬──────┬──────┬────────────────┐
* │ CLK   │ D   │ E   │   RN │ QN   │ Description    │
* ├───────┼─────┼─────┼──────┼──────┼────────────────┤
* │ R     │ 0   │ 1   │    1 │ 1    │ Write 0        │
* ├───────┼─────┼─────┼──────┼──────┼────────────────┤
* │ R     │ 1   │ 1   │    1 │ 0    │ Write 1        │
* ├───────┼─────┼─────┼──────┼──────┼────────────────┤
* │ R     │ -   │ 0   │    1 │ QN   │ Write disabled │
* ├───────┼─────┼─────┼──────┼──────┼────────────────┤
* │ R     │ -   │ -   │    0 │ 1    │ Clear          │
* └───────┴─────┴─────┴──────┴──────┴────────────────┘
****************************************
.SUBCKT DFERQN_D2 D E RN CLK QN VDD VSS
*.PININFO CLK:I D:I E:I RN:I QN:O VDD:B VSS:B
MN0 n0 CLK VSS VSS sg13_lv_nmos w=6.4e-07 l=1.3e-07 ng=1
MP0 n0 CLK VDD VDD sg13_lv_pmos w=9.8e-07 l=1.3e-07 ng=1
MN1 n1 n0 VSS VSS sg13_lv_nmos w=3e-07 l=1.3e-07 ng=1
MP1 n1 n0 VDD VDD sg13_lv_pmos w=5e-07 l=1.3e-07 ng=1
MN2 n2 E VSS VSS sg13_lv_nmos w=1.5e-07 l=1.3e-07 ng=1
MP2 n2 E VDD VDD sg13_lv_pmos w=3e-07 l=1.3e-07 ng=1
MN3 n3 RN VSS VSS sg13_lv_nmos w=3e-07 l=1.3e-07
MN4 n4 E n3 VSS sg13_lv_nmos w=3e-07 l=1.3e-07
MN5 n5 D n4 VSS sg13_lv_nmos w=3e-07 l=1.3e-07
MN6 n6 n2 n3 VSS sg13_lv_nmos w=3e-07 l=1.3e-07
MN7 n5 n7 n6 VSS sg13_lv_nmos w=3e-07 l=1.3e-07
MN8 n8 n0 n5 VSS sg13_lv_nmos w=3e-07 l=1.3e-07
MP3 n9 RN VDD VDD sg13_lv_pmos w=4.2e-07 l=1.3e-07
MP4 n10 E VDD VDD sg13_lv_pmos w=4.2e-07 l=1.3e-07
MP5 n9 n7 n10 VDD sg13_lv_pmos w=4.2e-07 l=1.3e-07
MP6 n11 n2 VDD VDD sg13_lv_pmos w=4.2e-07 l=1.3e-07
MP7 n9 D n11 VDD sg13_lv_pmos w=4.2e-07 l=1.3e-07
MP8 n8 n1 n9 VDD sg13_lv_pmos w=4.2e-07 l=1.3e-07
MN9 n12 n8 VSS VSS sg13_lv_nmos w=4e-07 l=1.3e-07 ng=1
MP9 n12 n8 VDD VDD sg13_lv_pmos w=6e-07 l=1.3e-07 ng=1
MN10 n8 n1 n13 VSS sg13_lv_nmos w=1.5e-07 l=1.3e-07 ng=1
MN11 n13 n12 VSS VSS sg13_lv_nmos w=1.5e-07 l=1.3e-07 ng=1
MP10 n8 n0 n14 VDD sg13_lv_pmos w=2.3e-07 l=1.3e-07 ng=1
MP11 n14 n12 VDD VDD sg13_lv_pmos w=2.3e-07 l=1.3e-07 ng=1
MN12 n15 n1 n16 VSS sg13_lv_nmos w=6.4e-07 l=1.3e-07 ng=1
MN13 n16 n12 VSS VSS sg13_lv_nmos w=6.4e-07 l=1.3e-07 ng=1
MP12 n15 n0 n17 VDD sg13_lv_pmos w=9.8e-07 l=1.3e-07 ng=1
MP13 n17 n12 VDD VDD sg13_lv_pmos w=9.8e-07 l=1.3e-07 ng=1
MN14 n15 n1 n18 VSS sg13_lv_nmos w=6.4e-07 l=1.3e-07 ng=1
MN15 n18 n12 VSS VSS sg13_lv_nmos w=6.4e-07 l=1.3e-07 ng=1
MP14 n15 n0 n19 VDD sg13_lv_pmos w=9.8e-07 l=1.3e-07 ng=1
MP15 n19 n12 VDD VDD sg13_lv_pmos w=9.8e-07 l=1.3e-07 ng=1
MN16 n7 n15 VSS VSS sg13_lv_nmos w=6.4e-07 l=1.3e-07 ng=1
MP16 n7 n15 VDD VDD sg13_lv_pmos w=9.8e-07 l=1.3e-07 ng=1
MN17 n15 n0 n20 VSS sg13_lv_nmos w=1.5e-07 l=1.3e-07 ng=1
MN18 n20 n7 VSS VSS sg13_lv_nmos w=1.5e-07 l=1.3e-07 ng=1
MP17 n15 n1 n21 VDD sg13_lv_pmos w=1.5e-07 l=1.3e-07 ng=1
MP18 n21 n7 VDD VDD sg13_lv_pmos w=1.5e-07 l=1.3e-07 ng=1
MN19 QN n7 VSS VSS sg13_lv_nmos w=1.07e-06 l=1.3e-07 ng=1
MP19 QN n7 VDD VDD sg13_lv_pmos w=1.6e-06 l=1.3e-07 ng=1
.ENDS

****************************************
* Cell : DFERQN_DL
* Description : D flip-flop with enable, synchronous reset and output QN.
* ┌───────┬─────┬─────┬──────┬──────┬────────────────┐
* │ CLK   │ D   │ E   │   RN │ QN   │ Description    │
* ├───────┼─────┼─────┼──────┼──────┼────────────────┤
* │ R     │ 0   │ 1   │    1 │ 1    │ Write 0        │
* ├───────┼─────┼─────┼──────┼──────┼────────────────┤
* │ R     │ 1   │ 1   │    1 │ 0    │ Write 1        │
* ├───────┼─────┼─────┼──────┼──────┼────────────────┤
* │ R     │ -   │ 0   │    1 │ QN   │ Write disabled │
* ├───────┼─────┼─────┼──────┼──────┼────────────────┤
* │ R     │ -   │ -   │    0 │ 1    │ Clear          │
* └───────┴─────┴─────┴──────┴──────┴────────────────┘
****************************************
.SUBCKT DFERQN_DL D E RN CLK QN VDD VSS
*.PININFO CLK:I D:I E:I RN:I QN:O VDD:B VSS:B
MN0 n0 CLK VSS VSS sg13_lv_nmos w=3e-07 l=1.3e-07 ng=1
MP0 n0 CLK VDD VDD sg13_lv_pmos w=4.5e-07 l=1.3e-07 ng=1
MN1 n1 n0 VSS VSS sg13_lv_nmos w=1.5e-07 l=1.3e-07 ng=1
MP1 n1 n0 VDD VDD sg13_lv_pmos w=2.5e-07 l=1.3e-07 ng=1
MN2 n2 E VSS VSS sg13_lv_nmos w=1.5e-07 l=1.3e-07 ng=1
MP2 n2 E VDD VDD sg13_lv_pmos w=2.3e-07 l=1.3e-07 ng=1
MN3 n3 RN VSS VSS sg13_lv_nmos w=1.5e-07 l=1.3e-07
MN4 n4 E n3 VSS sg13_lv_nmos w=1.5e-07 l=1.3e-07
MN5 n5 D n4 VSS sg13_lv_nmos w=1.5e-07 l=1.3e-07
MN6 n6 n2 n3 VSS sg13_lv_nmos w=1.5e-07 l=1.3e-07
MN7 n5 n7 n6 VSS sg13_lv_nmos w=1.5e-07 l=1.3e-07
MN8 n8 n0 n5 VSS sg13_lv_nmos w=1.5e-07 l=1.3e-07
MP3 n9 RN VDD VDD sg13_lv_pmos w=2e-07 l=1.3e-07
MP4 n10 E VDD VDD sg13_lv_pmos w=2e-07 l=1.3e-07
MP5 n9 n7 n10 VDD sg13_lv_pmos w=2e-07 l=1.3e-07
MP6 n11 n2 VDD VDD sg13_lv_pmos w=2e-07 l=1.3e-07
MP7 n9 D n11 VDD sg13_lv_pmos w=2e-07 l=1.3e-07
MP8 n8 n1 n9 VDD sg13_lv_pmos w=2e-07 l=1.3e-07
MN9 n12 n8 VSS VSS sg13_lv_nmos w=2e-07 l=1.3e-07 ng=1
MP9 n12 n8 VDD VDD sg13_lv_pmos w=4e-07 l=1.3e-07 ng=1
MN10 n8 n1 n13 VSS sg13_lv_nmos w=1.5e-07 l=1.3e-07 ng=1
MN11 n13 n12 VSS VSS sg13_lv_nmos w=1.5e-07 l=1.3e-07 ng=1
MP10 n8 n0 n14 VDD sg13_lv_pmos w=3e-07 l=1.3e-07 ng=1
MP11 n14 n12 VDD VDD sg13_lv_pmos w=3e-07 l=1.3e-07 ng=1
MN12 n15 n1 n16 VSS sg13_lv_nmos w=6e-07 l=1.3e-07 ng=1
MN13 n16 n12 VSS VSS sg13_lv_nmos w=6e-07 l=1.3e-07 ng=1
MP12 n15 n0 n17 VDD sg13_lv_pmos w=9e-07 l=1.3e-07 ng=1
MP13 n17 n12 VDD VDD sg13_lv_pmos w=9e-07 l=1.3e-07 ng=1
MN14 n7 n15 VSS VSS sg13_lv_nmos w=3e-07 l=1.3e-07 ng=1
MP14 n7 n15 VDD VDD sg13_lv_pmos w=5e-07 l=1.3e-07 ng=1
MN15 n15 n0 n18 VSS sg13_lv_nmos w=1.5e-07 l=1.3e-07 ng=1
MN16 n18 n7 VSS VSS sg13_lv_nmos w=1.5e-07 l=1.3e-07 ng=1
MP15 n15 n1 n19 VDD sg13_lv_pmos w=1.5e-07 l=1.3e-07 ng=1
MP16 n19 n7 VDD VDD sg13_lv_pmos w=1.5e-07 l=1.3e-07 ng=1
MN17 QN n7 VSS VSS sg13_lv_nmos w=3.2e-07 l=1.3e-07 ng=1
MP17 QN n7 VDD VDD sg13_lv_pmos w=4.9e-07 l=1.3e-07 ng=1
.ENDS

****************************************
* Cell : DFERQQN_D1
* Description : D flip-flop with enable, synchronous reset and outputs Q and QN.
* ┌───────┬─────┬─────┬──────┬─────┬──────┬────────────────┐
* │ CLK   │ D   │ E   │   RN │ Q   │ QN   │ Description    │
* ├───────┼─────┼─────┼──────┼─────┼──────┼────────────────┤
* │ R     │ 0   │ 1   │    1 │ 0   │ 1    │ Write 0        │
* ├───────┼─────┼─────┼──────┼─────┼──────┼────────────────┤
* │ R     │ 1   │ 1   │    1 │ 1   │ 0    │ Write 1        │
* ├───────┼─────┼─────┼──────┼─────┼──────┼────────────────┤
* │ R     │ -   │ 0   │    1 │ Q   │ QN   │ Write disabled │
* ├───────┼─────┼─────┼──────┼─────┼──────┼────────────────┤
* │ R     │ -   │ -   │    0 │ 0   │ 1    │ Clear          │
* └───────┴─────┴─────┴──────┴─────┴──────┴────────────────┘
****************************************
.SUBCKT DFERQQN_D1 D E RN CLK Q QN VDD VSS
*.PININFO CLK:I D:I E:I RN:I Q:O QN:O VDD:B VSS:B
MN0 n0 CLK VSS VSS sg13_lv_nmos w=3e-07 l=1.3e-07 ng=1
MP0 n0 CLK VDD VDD sg13_lv_pmos w=4.5e-07 l=1.3e-07 ng=1
MN1 n1 n0 VSS VSS sg13_lv_nmos w=1.5e-07 l=1.3e-07 ng=1
MP1 n1 n0 VDD VDD sg13_lv_pmos w=2.5e-07 l=1.3e-07 ng=1
MN2 n2 E VSS VSS sg13_lv_nmos w=1.5e-07 l=1.3e-07 ng=1
MP2 n2 E VDD VDD sg13_lv_pmos w=2.3e-07 l=1.3e-07 ng=1
MN3 n3 RN VSS VSS sg13_lv_nmos w=1.5e-07 l=1.3e-07
MN4 n4 E n3 VSS sg13_lv_nmos w=1.5e-07 l=1.3e-07
MN5 n5 D n4 VSS sg13_lv_nmos w=1.5e-07 l=1.3e-07
MN6 n6 n2 n3 VSS sg13_lv_nmos w=1.5e-07 l=1.3e-07
MN7 n5 n7 n6 VSS sg13_lv_nmos w=1.5e-07 l=1.3e-07
MN8 n8 n0 n5 VSS sg13_lv_nmos w=1.5e-07 l=1.3e-07
MP3 n9 RN VDD VDD sg13_lv_pmos w=2e-07 l=1.3e-07
MP4 n10 E VDD VDD sg13_lv_pmos w=2e-07 l=1.3e-07
MP5 n9 n7 n10 VDD sg13_lv_pmos w=2e-07 l=1.3e-07
MP6 n11 n2 VDD VDD sg13_lv_pmos w=2e-07 l=1.3e-07
MP7 n9 D n11 VDD sg13_lv_pmos w=2e-07 l=1.3e-07
MP8 n8 n1 n9 VDD sg13_lv_pmos w=2e-07 l=1.3e-07
MN9 n12 n8 VSS VSS sg13_lv_nmos w=2e-07 l=1.3e-07 ng=1
MP9 n12 n8 VDD VDD sg13_lv_pmos w=4e-07 l=1.3e-07 ng=1
MN10 n8 n1 n13 VSS sg13_lv_nmos w=1.5e-07 l=1.3e-07 ng=1
MN11 n13 n12 VSS VSS sg13_lv_nmos w=1.5e-07 l=1.3e-07 ng=1
MP10 n8 n0 n14 VDD sg13_lv_pmos w=3e-07 l=1.3e-07 ng=1
MP11 n14 n12 VDD VDD sg13_lv_pmos w=3e-07 l=1.3e-07 ng=1
MN12 n15 n1 n16 VSS sg13_lv_nmos w=6e-07 l=1.3e-07 ng=1
MN13 n16 n12 VSS VSS sg13_lv_nmos w=6e-07 l=1.3e-07 ng=1
MP12 n15 n0 n17 VDD sg13_lv_pmos w=9e-07 l=1.3e-07 ng=1
MP13 n17 n12 VDD VDD sg13_lv_pmos w=9e-07 l=1.3e-07 ng=1
MN14 n7 n15 VSS VSS sg13_lv_nmos w=3e-07 l=1.3e-07 ng=1
MP14 n7 n15 VDD VDD sg13_lv_pmos w=5e-07 l=1.3e-07 ng=1
MN15 n15 n0 n18 VSS sg13_lv_nmos w=1.5e-07 l=1.3e-07 ng=1
MN16 n18 n7 VSS VSS sg13_lv_nmos w=1.5e-07 l=1.3e-07 ng=1
MP15 n15 n1 n19 VDD sg13_lv_pmos w=1.5e-07 l=1.3e-07 ng=1
MP16 n19 n7 VDD VDD sg13_lv_pmos w=1.5e-07 l=1.3e-07 ng=1
MN17 Q n15 VSS VSS sg13_lv_nmos w=6.4e-07 l=1.3e-07 ng=1
MP17 Q n15 VDD VDD sg13_lv_pmos w=9.8e-07 l=1.3e-07 ng=1
MN18 QN n7 VSS VSS sg13_lv_nmos w=6.4e-07 l=1.3e-07 ng=1
MP18 QN n7 VDD VDD sg13_lv_pmos w=9.8e-07 l=1.3e-07 ng=1
.ENDS

****************************************
* Cell : DFERQQN_D2
* Description : D flip-flop with enable, synchronous reset and outputs Q and QN.
* ┌───────┬─────┬─────┬──────┬─────┬──────┬────────────────┐
* │ CLK   │ D   │ E   │   RN │ Q   │ QN   │ Description    │
* ├───────┼─────┼─────┼──────┼─────┼──────┼────────────────┤
* │ R     │ 0   │ 1   │    1 │ 0   │ 1    │ Write 0        │
* ├───────┼─────┼─────┼──────┼─────┼──────┼────────────────┤
* │ R     │ 1   │ 1   │    1 │ 1   │ 0    │ Write 1        │
* ├───────┼─────┼─────┼──────┼─────┼──────┼────────────────┤
* │ R     │ -   │ 0   │    1 │ Q   │ QN   │ Write disabled │
* ├───────┼─────┼─────┼──────┼─────┼──────┼────────────────┤
* │ R     │ -   │ -   │    0 │ 0   │ 1    │ Clear          │
* └───────┴─────┴─────┴──────┴─────┴──────┴────────────────┘
****************************************
.SUBCKT DFERQQN_D2 D E RN CLK Q QN VDD VSS
*.PININFO CLK:I D:I E:I RN:I Q:O QN:O VDD:B VSS:B
MN0 n0 CLK VSS VSS sg13_lv_nmos w=6.4e-07 l=1.3e-07 ng=1
MP0 n0 CLK VDD VDD sg13_lv_pmos w=9.8e-07 l=1.3e-07 ng=1
MN1 n1 n0 VSS VSS sg13_lv_nmos w=3e-07 l=1.3e-07 ng=1
MP1 n1 n0 VDD VDD sg13_lv_pmos w=5e-07 l=1.3e-07 ng=1
MN2 n2 E VSS VSS sg13_lv_nmos w=1.5e-07 l=1.3e-07 ng=1
MP2 n2 E VDD VDD sg13_lv_pmos w=3e-07 l=1.3e-07 ng=1
MN3 n3 RN VSS VSS sg13_lv_nmos w=3e-07 l=1.3e-07
MN4 n4 E n3 VSS sg13_lv_nmos w=3e-07 l=1.3e-07
MN5 n5 D n4 VSS sg13_lv_nmos w=3e-07 l=1.3e-07
MN6 n6 n2 n3 VSS sg13_lv_nmos w=3e-07 l=1.3e-07
MN7 n5 n7 n6 VSS sg13_lv_nmos w=3e-07 l=1.3e-07
MN8 n8 n0 n5 VSS sg13_lv_nmos w=3e-07 l=1.3e-07
MP3 n9 RN VDD VDD sg13_lv_pmos w=4.2e-07 l=1.3e-07
MP4 n10 E VDD VDD sg13_lv_pmos w=4.2e-07 l=1.3e-07
MP5 n9 n7 n10 VDD sg13_lv_pmos w=4.2e-07 l=1.3e-07
MP6 n11 n2 VDD VDD sg13_lv_pmos w=4.2e-07 l=1.3e-07
MP7 n9 D n11 VDD sg13_lv_pmos w=4.2e-07 l=1.3e-07
MP8 n8 n1 n9 VDD sg13_lv_pmos w=4.2e-07 l=1.3e-07
MN9 n12 n8 VSS VSS sg13_lv_nmos w=4e-07 l=1.3e-07 ng=1
MP9 n12 n8 VDD VDD sg13_lv_pmos w=6e-07 l=1.3e-07 ng=1
MN10 n8 n1 n13 VSS sg13_lv_nmos w=1.5e-07 l=1.3e-07 ng=1
MN11 n13 n12 VSS VSS sg13_lv_nmos w=1.5e-07 l=1.3e-07 ng=1
MP10 n8 n0 n14 VDD sg13_lv_pmos w=2.3e-07 l=1.3e-07 ng=1
MP11 n14 n12 VDD VDD sg13_lv_pmos w=2.3e-07 l=1.3e-07 ng=1
MN12 n15 n1 n16 VSS sg13_lv_nmos w=6.4e-07 l=1.3e-07 ng=1
MN13 n16 n12 VSS VSS sg13_lv_nmos w=6.4e-07 l=1.3e-07 ng=1
MP12 n15 n0 n17 VDD sg13_lv_pmos w=9.8e-07 l=1.3e-07 ng=1
MP13 n17 n12 VDD VDD sg13_lv_pmos w=9.8e-07 l=1.3e-07 ng=1
MN14 n15 n1 n18 VSS sg13_lv_nmos w=6.4e-07 l=1.3e-07 ng=1
MN15 n18 n12 VSS VSS sg13_lv_nmos w=6.4e-07 l=1.3e-07 ng=1
MP14 n15 n0 n19 VDD sg13_lv_pmos w=9.8e-07 l=1.3e-07 ng=1
MP15 n19 n12 VDD VDD sg13_lv_pmos w=9.8e-07 l=1.3e-07 ng=1
MN16 n7 n15 VSS VSS sg13_lv_nmos w=6.4e-07 l=1.3e-07 ng=1
MP16 n7 n15 VDD VDD sg13_lv_pmos w=9.8e-07 l=1.3e-07 ng=1
MN17 n15 n0 n20 VSS sg13_lv_nmos w=1.5e-07 l=1.3e-07 ng=1
MN18 n20 n7 VSS VSS sg13_lv_nmos w=1.5e-07 l=1.3e-07 ng=1
MP17 n15 n1 n21 VDD sg13_lv_pmos w=1.5e-07 l=1.3e-07 ng=1
MP18 n21 n7 VDD VDD sg13_lv_pmos w=1.5e-07 l=1.3e-07 ng=1
MN19 Q n15 VSS VSS sg13_lv_nmos w=1.07e-06 l=1.3e-07 ng=1
MP19 Q n15 VDD VDD sg13_lv_pmos w=1.6e-06 l=1.3e-07 ng=1
MN20 QN n7 VSS VSS sg13_lv_nmos w=1.07e-06 l=1.3e-07 ng=1
MP20 QN n7 VDD VDD sg13_lv_pmos w=1.6e-06 l=1.3e-07 ng=1
.ENDS

****************************************
* Cell : DFERQQN_DL
* Description : D flip-flop with enable, synchronous reset and outputs Q and QN.
* ┌───────┬─────┬─────┬──────┬─────┬──────┬────────────────┐
* │ CLK   │ D   │ E   │   RN │ Q   │ QN   │ Description    │
* ├───────┼─────┼─────┼──────┼─────┼──────┼────────────────┤
* │ R     │ 0   │ 1   │    1 │ 0   │ 1    │ Write 0        │
* ├───────┼─────┼─────┼──────┼─────┼──────┼────────────────┤
* │ R     │ 1   │ 1   │    1 │ 1   │ 0    │ Write 1        │
* ├───────┼─────┼─────┼──────┼─────┼──────┼────────────────┤
* │ R     │ -   │ 0   │    1 │ Q   │ QN   │ Write disabled │
* ├───────┼─────┼─────┼──────┼─────┼──────┼────────────────┤
* │ R     │ -   │ -   │    0 │ 0   │ 1    │ Clear          │
* └───────┴─────┴─────┴──────┴─────┴──────┴────────────────┘
****************************************
.SUBCKT DFERQQN_DL D E RN CLK Q QN VDD VSS
*.PININFO CLK:I D:I E:I RN:I Q:O QN:O VDD:B VSS:B
MN0 n0 CLK VSS VSS sg13_lv_nmos w=3e-07 l=1.3e-07 ng=1
MP0 n0 CLK VDD VDD sg13_lv_pmos w=4.5e-07 l=1.3e-07 ng=1
MN1 n1 n0 VSS VSS sg13_lv_nmos w=1.5e-07 l=1.3e-07 ng=1
MP1 n1 n0 VDD VDD sg13_lv_pmos w=2.5e-07 l=1.3e-07 ng=1
MN2 n2 E VSS VSS sg13_lv_nmos w=1.5e-07 l=1.3e-07 ng=1
MP2 n2 E VDD VDD sg13_lv_pmos w=2.3e-07 l=1.3e-07 ng=1
MN3 n3 RN VSS VSS sg13_lv_nmos w=1.5e-07 l=1.3e-07
MN4 n4 E n3 VSS sg13_lv_nmos w=1.5e-07 l=1.3e-07
MN5 n5 D n4 VSS sg13_lv_nmos w=1.5e-07 l=1.3e-07
MN6 n6 n2 n3 VSS sg13_lv_nmos w=1.5e-07 l=1.3e-07
MN7 n5 n7 n6 VSS sg13_lv_nmos w=1.5e-07 l=1.3e-07
MN8 n8 n0 n5 VSS sg13_lv_nmos w=1.5e-07 l=1.3e-07
MP3 n9 RN VDD VDD sg13_lv_pmos w=2e-07 l=1.3e-07
MP4 n10 E VDD VDD sg13_lv_pmos w=2e-07 l=1.3e-07
MP5 n9 n7 n10 VDD sg13_lv_pmos w=2e-07 l=1.3e-07
MP6 n11 n2 VDD VDD sg13_lv_pmos w=2e-07 l=1.3e-07
MP7 n9 D n11 VDD sg13_lv_pmos w=2e-07 l=1.3e-07
MP8 n8 n1 n9 VDD sg13_lv_pmos w=2e-07 l=1.3e-07
MN9 n12 n8 VSS VSS sg13_lv_nmos w=2e-07 l=1.3e-07 ng=1
MP9 n12 n8 VDD VDD sg13_lv_pmos w=4e-07 l=1.3e-07 ng=1
MN10 n8 n1 n13 VSS sg13_lv_nmos w=1.5e-07 l=1.3e-07 ng=1
MN11 n13 n12 VSS VSS sg13_lv_nmos w=1.5e-07 l=1.3e-07 ng=1
MP10 n8 n0 n14 VDD sg13_lv_pmos w=3e-07 l=1.3e-07 ng=1
MP11 n14 n12 VDD VDD sg13_lv_pmos w=3e-07 l=1.3e-07 ng=1
MN12 n15 n1 n16 VSS sg13_lv_nmos w=6e-07 l=1.3e-07 ng=1
MN13 n16 n12 VSS VSS sg13_lv_nmos w=6e-07 l=1.3e-07 ng=1
MP12 n15 n0 n17 VDD sg13_lv_pmos w=9e-07 l=1.3e-07 ng=1
MP13 n17 n12 VDD VDD sg13_lv_pmos w=9e-07 l=1.3e-07 ng=1
MN14 n7 n15 VSS VSS sg13_lv_nmos w=3e-07 l=1.3e-07 ng=1
MP14 n7 n15 VDD VDD sg13_lv_pmos w=5e-07 l=1.3e-07 ng=1
MN15 n15 n0 n18 VSS sg13_lv_nmos w=1.5e-07 l=1.3e-07 ng=1
MN16 n18 n7 VSS VSS sg13_lv_nmos w=1.5e-07 l=1.3e-07 ng=1
MP15 n15 n1 n19 VDD sg13_lv_pmos w=1.5e-07 l=1.3e-07 ng=1
MP16 n19 n7 VDD VDD sg13_lv_pmos w=1.5e-07 l=1.3e-07 ng=1
MN17 Q n15 VSS VSS sg13_lv_nmos w=3.2e-07 l=1.3e-07 ng=1
MP17 Q n15 VDD VDD sg13_lv_pmos w=4.9e-07 l=1.3e-07 ng=1
MN18 QN n7 VSS VSS sg13_lv_nmos w=3.2e-07 l=1.3e-07 ng=1
MP18 QN n7 VDD VDD sg13_lv_pmos w=4.9e-07 l=1.3e-07 ng=1
.ENDS

****************************************
* Cell : DFERQ_D1
* Description : D flip-flop with enable, synchronous reset and output Q.
* ┌───────┬─────┬─────┬──────┬─────┬────────────────┐
* │ CLK   │ D   │ E   │   RN │ Q   │ Description    │
* ├───────┼─────┼─────┼──────┼─────┼────────────────┤
* │ R     │ 0   │ 1   │    1 │ 0   │ Write 0        │
* ├───────┼─────┼─────┼──────┼─────┼────────────────┤
* │ R     │ 1   │ 1   │    1 │ 1   │ Write 1        │
* ├───────┼─────┼─────┼──────┼─────┼────────────────┤
* │ R     │ -   │ 0   │    1 │ Q   │ Write disabled │
* ├───────┼─────┼─────┼──────┼─────┼────────────────┤
* │ R     │ -   │ -   │    0 │ 0   │ Clear          │
* └───────┴─────┴─────┴──────┴─────┴────────────────┘
****************************************
.SUBCKT DFERQ_D1 D E RN CLK Q VDD VSS
*.PININFO CLK:I D:I E:I RN:I Q:O VDD:B VSS:B
MN0 n0 CLK VSS VSS sg13_lv_nmos w=3e-07 l=1.3e-07 ng=1
MP0 n0 CLK VDD VDD sg13_lv_pmos w=4.5e-07 l=1.3e-07 ng=1
MN1 n1 n0 VSS VSS sg13_lv_nmos w=1.5e-07 l=1.3e-07 ng=1
MP1 n1 n0 VDD VDD sg13_lv_pmos w=2.5e-07 l=1.3e-07 ng=1
MN2 n2 E VSS VSS sg13_lv_nmos w=1.5e-07 l=1.3e-07 ng=1
MP2 n2 E VDD VDD sg13_lv_pmos w=2.3e-07 l=1.3e-07 ng=1
MN3 n3 RN VSS VSS sg13_lv_nmos w=1.5e-07 l=1.3e-07
MN4 n4 E n3 VSS sg13_lv_nmos w=1.5e-07 l=1.3e-07
MN5 n5 D n4 VSS sg13_lv_nmos w=1.5e-07 l=1.3e-07
MN6 n6 n2 n3 VSS sg13_lv_nmos w=1.5e-07 l=1.3e-07
MN7 n5 n7 n6 VSS sg13_lv_nmos w=1.5e-07 l=1.3e-07
MN8 n8 n0 n5 VSS sg13_lv_nmos w=1.5e-07 l=1.3e-07
MP3 n9 RN VDD VDD sg13_lv_pmos w=2e-07 l=1.3e-07
MP4 n10 E VDD VDD sg13_lv_pmos w=2e-07 l=1.3e-07
MP5 n9 n7 n10 VDD sg13_lv_pmos w=2e-07 l=1.3e-07
MP6 n11 n2 VDD VDD sg13_lv_pmos w=2e-07 l=1.3e-07
MP7 n9 D n11 VDD sg13_lv_pmos w=2e-07 l=1.3e-07
MP8 n8 n1 n9 VDD sg13_lv_pmos w=2e-07 l=1.3e-07
MN9 n12 n8 VSS VSS sg13_lv_nmos w=2e-07 l=1.3e-07 ng=1
MP9 n12 n8 VDD VDD sg13_lv_pmos w=4e-07 l=1.3e-07 ng=1
MN10 n8 n1 n13 VSS sg13_lv_nmos w=1.5e-07 l=1.3e-07 ng=1
MN11 n13 n12 VSS VSS sg13_lv_nmos w=1.5e-07 l=1.3e-07 ng=1
MP10 n8 n0 n14 VDD sg13_lv_pmos w=3e-07 l=1.3e-07 ng=1
MP11 n14 n12 VDD VDD sg13_lv_pmos w=3e-07 l=1.3e-07 ng=1
MN12 n15 n1 n16 VSS sg13_lv_nmos w=6e-07 l=1.3e-07 ng=1
MN13 n16 n12 VSS VSS sg13_lv_nmos w=6e-07 l=1.3e-07 ng=1
MP12 n15 n0 n17 VDD sg13_lv_pmos w=9e-07 l=1.3e-07 ng=1
MP13 n17 n12 VDD VDD sg13_lv_pmos w=9e-07 l=1.3e-07 ng=1
MN14 n7 n15 VSS VSS sg13_lv_nmos w=3e-07 l=1.3e-07 ng=1
MP14 n7 n15 VDD VDD sg13_lv_pmos w=5e-07 l=1.3e-07 ng=1
MN15 n15 n0 n18 VSS sg13_lv_nmos w=1.5e-07 l=1.3e-07 ng=1
MN16 n18 n7 VSS VSS sg13_lv_nmos w=1.5e-07 l=1.3e-07 ng=1
MP15 n15 n1 n19 VDD sg13_lv_pmos w=1.5e-07 l=1.3e-07 ng=1
MP16 n19 n7 VDD VDD sg13_lv_pmos w=1.5e-07 l=1.3e-07 ng=1
MN17 Q n15 VSS VSS sg13_lv_nmos w=6.4e-07 l=1.3e-07 ng=1
MP17 Q n15 VDD VDD sg13_lv_pmos w=9.8e-07 l=1.3e-07 ng=1
.ENDS

****************************************
* Cell : DFERQ_D2
* Description : D flip-flop with enable, synchronous reset and output Q.
* ┌───────┬─────┬─────┬──────┬─────┬────────────────┐
* │ CLK   │ D   │ E   │   RN │ Q   │ Description    │
* ├───────┼─────┼─────┼──────┼─────┼────────────────┤
* │ R     │ 0   │ 1   │    1 │ 0   │ Write 0        │
* ├───────┼─────┼─────┼──────┼─────┼────────────────┤
* │ R     │ 1   │ 1   │    1 │ 1   │ Write 1        │
* ├───────┼─────┼─────┼──────┼─────┼────────────────┤
* │ R     │ -   │ 0   │    1 │ Q   │ Write disabled │
* ├───────┼─────┼─────┼──────┼─────┼────────────────┤
* │ R     │ -   │ -   │    0 │ 0   │ Clear          │
* └───────┴─────┴─────┴──────┴─────┴────────────────┘
****************************************
.SUBCKT DFERQ_D2 D E RN CLK Q VDD VSS
*.PININFO CLK:I D:I E:I RN:I Q:O VDD:B VSS:B
MN0 n0 CLK VSS VSS sg13_lv_nmos w=6.4e-07 l=1.3e-07 ng=1
MP0 n0 CLK VDD VDD sg13_lv_pmos w=9.8e-07 l=1.3e-07 ng=1
MN1 n1 n0 VSS VSS sg13_lv_nmos w=3e-07 l=1.3e-07 ng=1
MP1 n1 n0 VDD VDD sg13_lv_pmos w=5e-07 l=1.3e-07 ng=1
MN2 n2 E VSS VSS sg13_lv_nmos w=1.5e-07 l=1.3e-07 ng=1
MP2 n2 E VDD VDD sg13_lv_pmos w=3e-07 l=1.3e-07 ng=1
MN3 n3 RN VSS VSS sg13_lv_nmos w=3e-07 l=1.3e-07
MN4 n4 E n3 VSS sg13_lv_nmos w=3e-07 l=1.3e-07
MN5 n5 D n4 VSS sg13_lv_nmos w=3e-07 l=1.3e-07
MN6 n6 n2 n3 VSS sg13_lv_nmos w=3e-07 l=1.3e-07
MN7 n5 n7 n6 VSS sg13_lv_nmos w=3e-07 l=1.3e-07
MN8 n8 n0 n5 VSS sg13_lv_nmos w=3e-07 l=1.3e-07
MP3 n9 RN VDD VDD sg13_lv_pmos w=4.2e-07 l=1.3e-07
MP4 n10 E VDD VDD sg13_lv_pmos w=4.2e-07 l=1.3e-07
MP5 n9 n7 n10 VDD sg13_lv_pmos w=4.2e-07 l=1.3e-07
MP6 n11 n2 VDD VDD sg13_lv_pmos w=4.2e-07 l=1.3e-07
MP7 n9 D n11 VDD sg13_lv_pmos w=4.2e-07 l=1.3e-07
MP8 n8 n1 n9 VDD sg13_lv_pmos w=4.2e-07 l=1.3e-07
MN9 n12 n8 VSS VSS sg13_lv_nmos w=4e-07 l=1.3e-07 ng=1
MP9 n12 n8 VDD VDD sg13_lv_pmos w=6e-07 l=1.3e-07 ng=1
MN10 n8 n1 n13 VSS sg13_lv_nmos w=1.5e-07 l=1.3e-07 ng=1
MN11 n13 n12 VSS VSS sg13_lv_nmos w=1.5e-07 l=1.3e-07 ng=1
MP10 n8 n0 n14 VDD sg13_lv_pmos w=2.3e-07 l=1.3e-07 ng=1
MP11 n14 n12 VDD VDD sg13_lv_pmos w=2.3e-07 l=1.3e-07 ng=1
MN12 n15 n1 n16 VSS sg13_lv_nmos w=6.4e-07 l=1.3e-07 ng=1
MN13 n16 n12 VSS VSS sg13_lv_nmos w=6.4e-07 l=1.3e-07 ng=1
MP12 n15 n0 n17 VDD sg13_lv_pmos w=9.8e-07 l=1.3e-07 ng=1
MP13 n17 n12 VDD VDD sg13_lv_pmos w=9.8e-07 l=1.3e-07 ng=1
MN14 n15 n1 n18 VSS sg13_lv_nmos w=6.4e-07 l=1.3e-07 ng=1
MN15 n18 n12 VSS VSS sg13_lv_nmos w=6.4e-07 l=1.3e-07 ng=1
MP14 n15 n0 n19 VDD sg13_lv_pmos w=9.8e-07 l=1.3e-07 ng=1
MP15 n19 n12 VDD VDD sg13_lv_pmos w=9.8e-07 l=1.3e-07 ng=1
MN16 n7 n15 VSS VSS sg13_lv_nmos w=6.4e-07 l=1.3e-07 ng=1
MP16 n7 n15 VDD VDD sg13_lv_pmos w=9.8e-07 l=1.3e-07 ng=1
MN17 n15 n0 n20 VSS sg13_lv_nmos w=1.5e-07 l=1.3e-07 ng=1
MN18 n20 n7 VSS VSS sg13_lv_nmos w=1.5e-07 l=1.3e-07 ng=1
MP17 n15 n1 n21 VDD sg13_lv_pmos w=1.5e-07 l=1.3e-07 ng=1
MP18 n21 n7 VDD VDD sg13_lv_pmos w=1.5e-07 l=1.3e-07 ng=1
MN19 Q n15 VSS VSS sg13_lv_nmos w=1.07e-06 l=1.3e-07 ng=1
MP19 Q n15 VDD VDD sg13_lv_pmos w=1.6e-06 l=1.3e-07 ng=1
.ENDS

****************************************
* Cell : DFERQ_DL
* Description : D flip-flop with enable, synchronous reset and output Q.
* ┌───────┬─────┬─────┬──────┬─────┬────────────────┐
* │ CLK   │ D   │ E   │   RN │ Q   │ Description    │
* ├───────┼─────┼─────┼──────┼─────┼────────────────┤
* │ R     │ 0   │ 1   │    1 │ 0   │ Write 0        │
* ├───────┼─────┼─────┼──────┼─────┼────────────────┤
* │ R     │ 1   │ 1   │    1 │ 1   │ Write 1        │
* ├───────┼─────┼─────┼──────┼─────┼────────────────┤
* │ R     │ -   │ 0   │    1 │ Q   │ Write disabled │
* ├───────┼─────┼─────┼──────┼─────┼────────────────┤
* │ R     │ -   │ -   │    0 │ 0   │ Clear          │
* └───────┴─────┴─────┴──────┴─────┴────────────────┘
****************************************
.SUBCKT DFERQ_DL D E RN CLK Q VDD VSS
*.PININFO CLK:I D:I E:I RN:I Q:O VDD:B VSS:B
MN0 n0 CLK VSS VSS sg13_lv_nmos w=3e-07 l=1.3e-07 ng=1
MP0 n0 CLK VDD VDD sg13_lv_pmos w=4.5e-07 l=1.3e-07 ng=1
MN1 n1 n0 VSS VSS sg13_lv_nmos w=1.5e-07 l=1.3e-07 ng=1
MP1 n1 n0 VDD VDD sg13_lv_pmos w=2.5e-07 l=1.3e-07 ng=1
MN2 n2 E VSS VSS sg13_lv_nmos w=1.5e-07 l=1.3e-07 ng=1
MP2 n2 E VDD VDD sg13_lv_pmos w=2.3e-07 l=1.3e-07 ng=1
MN3 n3 RN VSS VSS sg13_lv_nmos w=1.5e-07 l=1.3e-07
MN4 n4 E n3 VSS sg13_lv_nmos w=1.5e-07 l=1.3e-07
MN5 n5 D n4 VSS sg13_lv_nmos w=1.5e-07 l=1.3e-07
MN6 n6 n2 n3 VSS sg13_lv_nmos w=1.5e-07 l=1.3e-07
MN7 n5 n7 n6 VSS sg13_lv_nmos w=1.5e-07 l=1.3e-07
MN8 n8 n0 n5 VSS sg13_lv_nmos w=1.5e-07 l=1.3e-07
MP3 n9 RN VDD VDD sg13_lv_pmos w=2e-07 l=1.3e-07
MP4 n10 E VDD VDD sg13_lv_pmos w=2e-07 l=1.3e-07
MP5 n9 n7 n10 VDD sg13_lv_pmos w=2e-07 l=1.3e-07
MP6 n11 n2 VDD VDD sg13_lv_pmos w=2e-07 l=1.3e-07
MP7 n9 D n11 VDD sg13_lv_pmos w=2e-07 l=1.3e-07
MP8 n8 n1 n9 VDD sg13_lv_pmos w=2e-07 l=1.3e-07
MN9 n12 n8 VSS VSS sg13_lv_nmos w=2e-07 l=1.3e-07 ng=1
MP9 n12 n8 VDD VDD sg13_lv_pmos w=4e-07 l=1.3e-07 ng=1
MN10 n8 n1 n13 VSS sg13_lv_nmos w=1.5e-07 l=1.3e-07 ng=1
MN11 n13 n12 VSS VSS sg13_lv_nmos w=1.5e-07 l=1.3e-07 ng=1
MP10 n8 n0 n14 VDD sg13_lv_pmos w=3e-07 l=1.3e-07 ng=1
MP11 n14 n12 VDD VDD sg13_lv_pmos w=3e-07 l=1.3e-07 ng=1
MN12 n15 n1 n16 VSS sg13_lv_nmos w=6e-07 l=1.3e-07 ng=1
MN13 n16 n12 VSS VSS sg13_lv_nmos w=6e-07 l=1.3e-07 ng=1
MP12 n15 n0 n17 VDD sg13_lv_pmos w=9e-07 l=1.3e-07 ng=1
MP13 n17 n12 VDD VDD sg13_lv_pmos w=9e-07 l=1.3e-07 ng=1
MN14 n7 n15 VSS VSS sg13_lv_nmos w=3e-07 l=1.3e-07 ng=1
MP14 n7 n15 VDD VDD sg13_lv_pmos w=5e-07 l=1.3e-07 ng=1
MN15 n15 n0 n18 VSS sg13_lv_nmos w=1.5e-07 l=1.3e-07 ng=1
MN16 n18 n7 VSS VSS sg13_lv_nmos w=1.5e-07 l=1.3e-07 ng=1
MP15 n15 n1 n19 VDD sg13_lv_pmos w=1.5e-07 l=1.3e-07 ng=1
MP16 n19 n7 VDD VDD sg13_lv_pmos w=1.5e-07 l=1.3e-07 ng=1
MN17 Q n15 VSS VSS sg13_lv_nmos w=3.2e-07 l=1.3e-07 ng=1
MP17 Q n15 VDD VDD sg13_lv_pmos w=4.9e-07 l=1.3e-07 ng=1
.ENDS

****************************************
* Cell : DFESQN_D1
* Description : D flip-flop with enable, synchronous set and output QN.
* ┌───────┬─────┬─────┬─────┬──────┬────────────────┐
* │ CLK   │ D   │ E   │   S │ QN   │ Description    │
* ├───────┼─────┼─────┼─────┼──────┼────────────────┤
* │ R     │ 0   │ 1   │   0 │ 1    │ Write 0        │
* ├───────┼─────┼─────┼─────┼──────┼────────────────┤
* │ R     │ 1   │ 1   │   0 │ 0    │ Write 1        │
* ├───────┼─────┼─────┼─────┼──────┼────────────────┤
* │ R     │ -   │ 0   │   0 │ QN   │ Write disabled │
* ├───────┼─────┼─────┼─────┼──────┼────────────────┤
* │ R     │ -   │ -   │   1 │ 0    │ Set            │
* └───────┴─────┴─────┴─────┴──────┴────────────────┘
****************************************
.SUBCKT DFESQN_D1 D E S CLK QN VDD VSS
*.PININFO CLK:I D:I E:I S:I QN:O VDD:B VSS:B
MN0 n0 CLK VSS VSS sg13_lv_nmos w=3e-07 l=1.3e-07 ng=1
MP0 n0 CLK VDD VDD sg13_lv_pmos w=4.5e-07 l=1.3e-07 ng=1
MN1 n1 n0 VSS VSS sg13_lv_nmos w=1.5e-07 l=1.3e-07 ng=1
MP1 n1 n0 VDD VDD sg13_lv_pmos w=2.5e-07 l=1.3e-07 ng=1
MN2 n2 E VSS VSS sg13_lv_nmos w=1.5e-07 l=1.3e-07 ng=1
MP2 n2 E VDD VDD sg13_lv_pmos w=2.3e-07 l=1.3e-07 ng=1
MN3 n3 S VSS VSS sg13_lv_nmos w=1.5e-07 l=1.3e-07
MN4 n4 E VSS VSS sg13_lv_nmos w=1.5e-07 l=1.3e-07
MN5 n3 D n4 VSS sg13_lv_nmos w=1.5e-07 l=1.3e-07
MN6 n5 n2 VSS VSS sg13_lv_nmos w=1.5e-07 l=1.3e-07
MN7 n3 n6 n5 VSS sg13_lv_nmos w=1.5e-07 l=1.3e-07
MN8 n7 n0 n3 VSS sg13_lv_nmos w=1.5e-07 l=1.3e-07
MP3 n8 S VDD VDD sg13_lv_pmos w=2e-07 l=1.3e-07
MP4 n9 E n8 VDD sg13_lv_pmos w=2e-07 l=1.3e-07
MP5 n10 n6 n9 VDD sg13_lv_pmos w=2e-07 l=1.3e-07
MP6 n11 n2 n8 VDD sg13_lv_pmos w=2e-07 l=1.3e-07
MP7 n10 D n11 VDD sg13_lv_pmos w=2e-07 l=1.3e-07
MP8 n7 n1 n10 VDD sg13_lv_pmos w=2e-07 l=1.3e-07
MN9 n12 n7 VSS VSS sg13_lv_nmos w=2e-07 l=1.3e-07 ng=1
MP9 n12 n7 VDD VDD sg13_lv_pmos w=4e-07 l=1.3e-07 ng=1
MN10 n7 n1 n13 VSS sg13_lv_nmos w=1.5e-07 l=1.3e-07 ng=1
MN11 n13 n12 VSS VSS sg13_lv_nmos w=1.5e-07 l=1.3e-07 ng=1
MP10 n7 n0 n14 VDD sg13_lv_pmos w=3e-07 l=1.3e-07 ng=1
MP11 n14 n12 VDD VDD sg13_lv_pmos w=3e-07 l=1.3e-07 ng=1
MN12 n15 n1 n16 VSS sg13_lv_nmos w=6e-07 l=1.3e-07 ng=1
MN13 n16 n12 VSS VSS sg13_lv_nmos w=6e-07 l=1.3e-07 ng=1
MP12 n15 n0 n17 VDD sg13_lv_pmos w=9e-07 l=1.3e-07 ng=1
MP13 n17 n12 VDD VDD sg13_lv_pmos w=9e-07 l=1.3e-07 ng=1
MN14 n6 n15 VSS VSS sg13_lv_nmos w=3e-07 l=1.3e-07 ng=1
MP14 n6 n15 VDD VDD sg13_lv_pmos w=5e-07 l=1.3e-07 ng=1
MN15 n15 n0 n18 VSS sg13_lv_nmos w=1.5e-07 l=1.3e-07 ng=1
MN16 n18 n6 VSS VSS sg13_lv_nmos w=1.5e-07 l=1.3e-07 ng=1
MP15 n15 n1 n19 VDD sg13_lv_pmos w=1.5e-07 l=1.3e-07 ng=1
MP16 n19 n6 VDD VDD sg13_lv_pmos w=1.5e-07 l=1.3e-07 ng=1
MN17 QN n6 VSS VSS sg13_lv_nmos w=6.4e-07 l=1.3e-07 ng=1
MP17 QN n6 VDD VDD sg13_lv_pmos w=9.8e-07 l=1.3e-07 ng=1
.ENDS

****************************************
* Cell : DFESQN_D2
* Description : D flip-flop with enable, synchronous set and output QN.
* ┌───────┬─────┬─────┬─────┬──────┬────────────────┐
* │ CLK   │ D   │ E   │   S │ QN   │ Description    │
* ├───────┼─────┼─────┼─────┼──────┼────────────────┤
* │ R     │ 0   │ 1   │   0 │ 1    │ Write 0        │
* ├───────┼─────┼─────┼─────┼──────┼────────────────┤
* │ R     │ 1   │ 1   │   0 │ 0    │ Write 1        │
* ├───────┼─────┼─────┼─────┼──────┼────────────────┤
* │ R     │ -   │ 0   │   0 │ QN   │ Write disabled │
* ├───────┼─────┼─────┼─────┼──────┼────────────────┤
* │ R     │ -   │ -   │   1 │ 0    │ Set            │
* └───────┴─────┴─────┴─────┴──────┴────────────────┘
****************************************
.SUBCKT DFESQN_D2 D E S CLK QN VDD VSS
*.PININFO CLK:I D:I E:I S:I QN:O VDD:B VSS:B
MN0 n0 CLK VSS VSS sg13_lv_nmos w=6.4e-07 l=1.3e-07 ng=1
MP0 n0 CLK VDD VDD sg13_lv_pmos w=9.8e-07 l=1.3e-07 ng=1
MN1 n1 n0 VSS VSS sg13_lv_nmos w=3e-07 l=1.3e-07 ng=1
MP1 n1 n0 VDD VDD sg13_lv_pmos w=5e-07 l=1.3e-07 ng=1
MN2 n2 E VSS VSS sg13_lv_nmos w=1.5e-07 l=1.3e-07 ng=1
MP2 n2 E VDD VDD sg13_lv_pmos w=3e-07 l=1.3e-07 ng=1
MN3 n3 S VSS VSS sg13_lv_nmos w=3e-07 l=1.3e-07
MN4 n4 E VSS VSS sg13_lv_nmos w=3e-07 l=1.3e-07
MN5 n3 D n4 VSS sg13_lv_nmos w=3e-07 l=1.3e-07
MN6 n5 n2 VSS VSS sg13_lv_nmos w=3e-07 l=1.3e-07
MN7 n3 n6 n5 VSS sg13_lv_nmos w=3e-07 l=1.3e-07
MN8 n7 n0 n3 VSS sg13_lv_nmos w=3e-07 l=1.3e-07
MP3 n8 S VDD VDD sg13_lv_pmos w=4.2e-07 l=1.3e-07
MP4 n9 E n8 VDD sg13_lv_pmos w=4.2e-07 l=1.3e-07
MP5 n10 n6 n9 VDD sg13_lv_pmos w=4.2e-07 l=1.3e-07
MP6 n11 n2 n8 VDD sg13_lv_pmos w=4.2e-07 l=1.3e-07
MP7 n10 D n11 VDD sg13_lv_pmos w=4.2e-07 l=1.3e-07
MP8 n7 n1 n10 VDD sg13_lv_pmos w=4.2e-07 l=1.3e-07
MN9 n12 n7 VSS VSS sg13_lv_nmos w=4e-07 l=1.3e-07 ng=1
MP9 n12 n7 VDD VDD sg13_lv_pmos w=6e-07 l=1.3e-07 ng=1
MN10 n7 n1 n13 VSS sg13_lv_nmos w=1.5e-07 l=1.3e-07 ng=1
MN11 n13 n12 VSS VSS sg13_lv_nmos w=1.5e-07 l=1.3e-07 ng=1
MP10 n7 n0 n14 VDD sg13_lv_pmos w=2.3e-07 l=1.3e-07 ng=1
MP11 n14 n12 VDD VDD sg13_lv_pmos w=2.3e-07 l=1.3e-07 ng=1
MN12 n15 n1 n16 VSS sg13_lv_nmos w=6.4e-07 l=1.3e-07 ng=1
MN13 n16 n12 VSS VSS sg13_lv_nmos w=6.4e-07 l=1.3e-07 ng=1
MP12 n15 n0 n17 VDD sg13_lv_pmos w=9.8e-07 l=1.3e-07 ng=1
MP13 n17 n12 VDD VDD sg13_lv_pmos w=9.8e-07 l=1.3e-07 ng=1
MN14 n15 n1 n18 VSS sg13_lv_nmos w=6.4e-07 l=1.3e-07 ng=1
MN15 n18 n12 VSS VSS sg13_lv_nmos w=6.4e-07 l=1.3e-07 ng=1
MP14 n15 n0 n19 VDD sg13_lv_pmos w=9.8e-07 l=1.3e-07 ng=1
MP15 n19 n12 VDD VDD sg13_lv_pmos w=9.8e-07 l=1.3e-07 ng=1
MN16 n6 n15 VSS VSS sg13_lv_nmos w=6.4e-07 l=1.3e-07 ng=1
MP16 n6 n15 VDD VDD sg13_lv_pmos w=9.8e-07 l=1.3e-07 ng=1
MN17 n15 n0 n20 VSS sg13_lv_nmos w=1.5e-07 l=1.3e-07 ng=1
MN18 n20 n6 VSS VSS sg13_lv_nmos w=1.5e-07 l=1.3e-07 ng=1
MP17 n15 n1 n21 VDD sg13_lv_pmos w=1.5e-07 l=1.3e-07 ng=1
MP18 n21 n6 VDD VDD sg13_lv_pmos w=1.5e-07 l=1.3e-07 ng=1
MN19 QN n6 VSS VSS sg13_lv_nmos w=1.07e-06 l=1.3e-07 ng=1
MP19 QN n6 VDD VDD sg13_lv_pmos w=1.6e-06 l=1.3e-07 ng=1
.ENDS

****************************************
* Cell : DFESQN_DL
* Description : D flip-flop with enable, synchronous set and output QN.
* ┌───────┬─────┬─────┬─────┬──────┬────────────────┐
* │ CLK   │ D   │ E   │   S │ QN   │ Description    │
* ├───────┼─────┼─────┼─────┼──────┼────────────────┤
* │ R     │ 0   │ 1   │   0 │ 1    │ Write 0        │
* ├───────┼─────┼─────┼─────┼──────┼────────────────┤
* │ R     │ 1   │ 1   │   0 │ 0    │ Write 1        │
* ├───────┼─────┼─────┼─────┼──────┼────────────────┤
* │ R     │ -   │ 0   │   0 │ QN   │ Write disabled │
* ├───────┼─────┼─────┼─────┼──────┼────────────────┤
* │ R     │ -   │ -   │   1 │ 0    │ Set            │
* └───────┴─────┴─────┴─────┴──────┴────────────────┘
****************************************
.SUBCKT DFESQN_DL D E S CLK QN VDD VSS
*.PININFO CLK:I D:I E:I S:I QN:O VDD:B VSS:B
MN0 n0 CLK VSS VSS sg13_lv_nmos w=3e-07 l=1.3e-07 ng=1
MP0 n0 CLK VDD VDD sg13_lv_pmos w=4.5e-07 l=1.3e-07 ng=1
MN1 n1 n0 VSS VSS sg13_lv_nmos w=1.5e-07 l=1.3e-07 ng=1
MP1 n1 n0 VDD VDD sg13_lv_pmos w=2.5e-07 l=1.3e-07 ng=1
MN2 n2 E VSS VSS sg13_lv_nmos w=1.5e-07 l=1.3e-07 ng=1
MP2 n2 E VDD VDD sg13_lv_pmos w=2.3e-07 l=1.3e-07 ng=1
MN3 n3 S VSS VSS sg13_lv_nmos w=1.5e-07 l=1.3e-07
MN4 n4 E VSS VSS sg13_lv_nmos w=1.5e-07 l=1.3e-07
MN5 n3 D n4 VSS sg13_lv_nmos w=1.5e-07 l=1.3e-07
MN6 n5 n2 VSS VSS sg13_lv_nmos w=1.5e-07 l=1.3e-07
MN7 n3 n6 n5 VSS sg13_lv_nmos w=1.5e-07 l=1.3e-07
MN8 n7 n0 n3 VSS sg13_lv_nmos w=1.5e-07 l=1.3e-07
MP3 n8 S VDD VDD sg13_lv_pmos w=2e-07 l=1.3e-07
MP4 n9 E n8 VDD sg13_lv_pmos w=2e-07 l=1.3e-07
MP5 n10 n6 n9 VDD sg13_lv_pmos w=2e-07 l=1.3e-07
MP6 n11 n2 n8 VDD sg13_lv_pmos w=2e-07 l=1.3e-07
MP7 n10 D n11 VDD sg13_lv_pmos w=2e-07 l=1.3e-07
MP8 n7 n1 n10 VDD sg13_lv_pmos w=2e-07 l=1.3e-07
MN9 n12 n7 VSS VSS sg13_lv_nmos w=2e-07 l=1.3e-07 ng=1
MP9 n12 n7 VDD VDD sg13_lv_pmos w=4e-07 l=1.3e-07 ng=1
MN10 n7 n1 n13 VSS sg13_lv_nmos w=1.5e-07 l=1.3e-07 ng=1
MN11 n13 n12 VSS VSS sg13_lv_nmos w=1.5e-07 l=1.3e-07 ng=1
MP10 n7 n0 n14 VDD sg13_lv_pmos w=3e-07 l=1.3e-07 ng=1
MP11 n14 n12 VDD VDD sg13_lv_pmos w=3e-07 l=1.3e-07 ng=1
MN12 n15 n1 n16 VSS sg13_lv_nmos w=6e-07 l=1.3e-07 ng=1
MN13 n16 n12 VSS VSS sg13_lv_nmos w=6e-07 l=1.3e-07 ng=1
MP12 n15 n0 n17 VDD sg13_lv_pmos w=9e-07 l=1.3e-07 ng=1
MP13 n17 n12 VDD VDD sg13_lv_pmos w=9e-07 l=1.3e-07 ng=1
MN14 n6 n15 VSS VSS sg13_lv_nmos w=3e-07 l=1.3e-07 ng=1
MP14 n6 n15 VDD VDD sg13_lv_pmos w=5e-07 l=1.3e-07 ng=1
MN15 n15 n0 n18 VSS sg13_lv_nmos w=1.5e-07 l=1.3e-07 ng=1
MN16 n18 n6 VSS VSS sg13_lv_nmos w=1.5e-07 l=1.3e-07 ng=1
MP15 n15 n1 n19 VDD sg13_lv_pmos w=1.5e-07 l=1.3e-07 ng=1
MP16 n19 n6 VDD VDD sg13_lv_pmos w=1.5e-07 l=1.3e-07 ng=1
MN17 QN n6 VSS VSS sg13_lv_nmos w=3.2e-07 l=1.3e-07 ng=1
MP17 QN n6 VDD VDD sg13_lv_pmos w=4.9e-07 l=1.3e-07 ng=1
.ENDS

****************************************
* Cell : DFESQQN_D1
* Description : D flip-flop with enable, synchronous set and outputs Q and QN.
* ┌───────┬─────┬─────┬─────┬─────┬──────┬────────────────┐
* │ CLK   │ D   │ E   │   S │ Q   │ QN   │ Description    │
* ├───────┼─────┼─────┼─────┼─────┼──────┼────────────────┤
* │ R     │ 0   │ 1   │   0 │ 0   │ 1    │ Write 0        │
* ├───────┼─────┼─────┼─────┼─────┼──────┼────────────────┤
* │ R     │ 1   │ 1   │   0 │ 1   │ 0    │ Write 1        │
* ├───────┼─────┼─────┼─────┼─────┼──────┼────────────────┤
* │ R     │ -   │ 0   │   0 │ Q   │ QN   │ Write disabled │
* ├───────┼─────┼─────┼─────┼─────┼──────┼────────────────┤
* │ R     │ -   │ -   │   1 │ 1   │ 0    │ Set            │
* └───────┴─────┴─────┴─────┴─────┴──────┴────────────────┘
****************************************
.SUBCKT DFESQQN_D1 D E S CLK Q QN VDD VSS
*.PININFO CLK:I D:I E:I S:I Q:O QN:O VDD:B VSS:B
MN0 n0 CLK VSS VSS sg13_lv_nmos w=3e-07 l=1.3e-07 ng=1
MP0 n0 CLK VDD VDD sg13_lv_pmos w=4.5e-07 l=1.3e-07 ng=1
MN1 n1 n0 VSS VSS sg13_lv_nmos w=1.5e-07 l=1.3e-07 ng=1
MP1 n1 n0 VDD VDD sg13_lv_pmos w=2.5e-07 l=1.3e-07 ng=1
MN2 n2 E VSS VSS sg13_lv_nmos w=1.5e-07 l=1.3e-07 ng=1
MP2 n2 E VDD VDD sg13_lv_pmos w=2.3e-07 l=1.3e-07 ng=1
MN3 n3 S VSS VSS sg13_lv_nmos w=1.5e-07 l=1.3e-07
MN4 n4 E VSS VSS sg13_lv_nmos w=1.5e-07 l=1.3e-07
MN5 n3 D n4 VSS sg13_lv_nmos w=1.5e-07 l=1.3e-07
MN6 n5 n2 VSS VSS sg13_lv_nmos w=1.5e-07 l=1.3e-07
MN7 n3 n6 n5 VSS sg13_lv_nmos w=1.5e-07 l=1.3e-07
MN8 n7 n0 n3 VSS sg13_lv_nmos w=1.5e-07 l=1.3e-07
MP3 n8 S VDD VDD sg13_lv_pmos w=2e-07 l=1.3e-07
MP4 n9 E n8 VDD sg13_lv_pmos w=2e-07 l=1.3e-07
MP5 n10 n6 n9 VDD sg13_lv_pmos w=2e-07 l=1.3e-07
MP6 n11 n2 n8 VDD sg13_lv_pmos w=2e-07 l=1.3e-07
MP7 n10 D n11 VDD sg13_lv_pmos w=2e-07 l=1.3e-07
MP8 n7 n1 n10 VDD sg13_lv_pmos w=2e-07 l=1.3e-07
MN9 n12 n7 VSS VSS sg13_lv_nmos w=2e-07 l=1.3e-07 ng=1
MP9 n12 n7 VDD VDD sg13_lv_pmos w=4e-07 l=1.3e-07 ng=1
MN10 n7 n1 n13 VSS sg13_lv_nmos w=1.5e-07 l=1.3e-07 ng=1
MN11 n13 n12 VSS VSS sg13_lv_nmos w=1.5e-07 l=1.3e-07 ng=1
MP10 n7 n0 n14 VDD sg13_lv_pmos w=3e-07 l=1.3e-07 ng=1
MP11 n14 n12 VDD VDD sg13_lv_pmos w=3e-07 l=1.3e-07 ng=1
MN12 n15 n1 n16 VSS sg13_lv_nmos w=6e-07 l=1.3e-07 ng=1
MN13 n16 n12 VSS VSS sg13_lv_nmos w=6e-07 l=1.3e-07 ng=1
MP12 n15 n0 n17 VDD sg13_lv_pmos w=9e-07 l=1.3e-07 ng=1
MP13 n17 n12 VDD VDD sg13_lv_pmos w=9e-07 l=1.3e-07 ng=1
MN14 n6 n15 VSS VSS sg13_lv_nmos w=3e-07 l=1.3e-07 ng=1
MP14 n6 n15 VDD VDD sg13_lv_pmos w=5e-07 l=1.3e-07 ng=1
MN15 n15 n0 n18 VSS sg13_lv_nmos w=1.5e-07 l=1.3e-07 ng=1
MN16 n18 n6 VSS VSS sg13_lv_nmos w=1.5e-07 l=1.3e-07 ng=1
MP15 n15 n1 n19 VDD sg13_lv_pmos w=1.5e-07 l=1.3e-07 ng=1
MP16 n19 n6 VDD VDD sg13_lv_pmos w=1.5e-07 l=1.3e-07 ng=1
MN17 Q n15 VSS VSS sg13_lv_nmos w=6.4e-07 l=1.3e-07 ng=1
MP17 Q n15 VDD VDD sg13_lv_pmos w=9.8e-07 l=1.3e-07 ng=1
MN18 QN n6 VSS VSS sg13_lv_nmos w=6.4e-07 l=1.3e-07 ng=1
MP18 QN n6 VDD VDD sg13_lv_pmos w=9.8e-07 l=1.3e-07 ng=1
.ENDS

****************************************
* Cell : DFESQQN_D2
* Description : D flip-flop with enable, synchronous set and outputs Q and QN.
* ┌───────┬─────┬─────┬─────┬─────┬──────┬────────────────┐
* │ CLK   │ D   │ E   │   S │ Q   │ QN   │ Description    │
* ├───────┼─────┼─────┼─────┼─────┼──────┼────────────────┤
* │ R     │ 0   │ 1   │   0 │ 0   │ 1    │ Write 0        │
* ├───────┼─────┼─────┼─────┼─────┼──────┼────────────────┤
* │ R     │ 1   │ 1   │   0 │ 1   │ 0    │ Write 1        │
* ├───────┼─────┼─────┼─────┼─────┼──────┼────────────────┤
* │ R     │ -   │ 0   │   0 │ Q   │ QN   │ Write disabled │
* ├───────┼─────┼─────┼─────┼─────┼──────┼────────────────┤
* │ R     │ -   │ -   │   1 │ 1   │ 0    │ Set            │
* └───────┴─────┴─────┴─────┴─────┴──────┴────────────────┘
****************************************
.SUBCKT DFESQQN_D2 D E S CLK Q QN VDD VSS
*.PININFO CLK:I D:I E:I S:I Q:O QN:O VDD:B VSS:B
MN0 n0 CLK VSS VSS sg13_lv_nmos w=6.4e-07 l=1.3e-07 ng=1
MP0 n0 CLK VDD VDD sg13_lv_pmos w=9.8e-07 l=1.3e-07 ng=1
MN1 n1 n0 VSS VSS sg13_lv_nmos w=3e-07 l=1.3e-07 ng=1
MP1 n1 n0 VDD VDD sg13_lv_pmos w=5e-07 l=1.3e-07 ng=1
MN2 n2 E VSS VSS sg13_lv_nmos w=1.5e-07 l=1.3e-07 ng=1
MP2 n2 E VDD VDD sg13_lv_pmos w=3e-07 l=1.3e-07 ng=1
MN3 n3 S VSS VSS sg13_lv_nmos w=3e-07 l=1.3e-07
MN4 n4 E VSS VSS sg13_lv_nmos w=3e-07 l=1.3e-07
MN5 n3 D n4 VSS sg13_lv_nmos w=3e-07 l=1.3e-07
MN6 n5 n2 VSS VSS sg13_lv_nmos w=3e-07 l=1.3e-07
MN7 n3 n6 n5 VSS sg13_lv_nmos w=3e-07 l=1.3e-07
MN8 n7 n0 n3 VSS sg13_lv_nmos w=3e-07 l=1.3e-07
MP3 n8 S VDD VDD sg13_lv_pmos w=4.2e-07 l=1.3e-07
MP4 n9 E n8 VDD sg13_lv_pmos w=4.2e-07 l=1.3e-07
MP5 n10 n6 n9 VDD sg13_lv_pmos w=4.2e-07 l=1.3e-07
MP6 n11 n2 n8 VDD sg13_lv_pmos w=4.2e-07 l=1.3e-07
MP7 n10 D n11 VDD sg13_lv_pmos w=4.2e-07 l=1.3e-07
MP8 n7 n1 n10 VDD sg13_lv_pmos w=4.2e-07 l=1.3e-07
MN9 n12 n7 VSS VSS sg13_lv_nmos w=4e-07 l=1.3e-07 ng=1
MP9 n12 n7 VDD VDD sg13_lv_pmos w=6e-07 l=1.3e-07 ng=1
MN10 n7 n1 n13 VSS sg13_lv_nmos w=1.5e-07 l=1.3e-07 ng=1
MN11 n13 n12 VSS VSS sg13_lv_nmos w=1.5e-07 l=1.3e-07 ng=1
MP10 n7 n0 n14 VDD sg13_lv_pmos w=2.3e-07 l=1.3e-07 ng=1
MP11 n14 n12 VDD VDD sg13_lv_pmos w=2.3e-07 l=1.3e-07 ng=1
MN12 n15 n1 n16 VSS sg13_lv_nmos w=6.4e-07 l=1.3e-07 ng=1
MN13 n16 n12 VSS VSS sg13_lv_nmos w=6.4e-07 l=1.3e-07 ng=1
MP12 n15 n0 n17 VDD sg13_lv_pmos w=9.8e-07 l=1.3e-07 ng=1
MP13 n17 n12 VDD VDD sg13_lv_pmos w=9.8e-07 l=1.3e-07 ng=1
MN14 n15 n1 n18 VSS sg13_lv_nmos w=6.4e-07 l=1.3e-07 ng=1
MN15 n18 n12 VSS VSS sg13_lv_nmos w=6.4e-07 l=1.3e-07 ng=1
MP14 n15 n0 n19 VDD sg13_lv_pmos w=9.8e-07 l=1.3e-07 ng=1
MP15 n19 n12 VDD VDD sg13_lv_pmos w=9.8e-07 l=1.3e-07 ng=1
MN16 n6 n15 VSS VSS sg13_lv_nmos w=6.4e-07 l=1.3e-07 ng=1
MP16 n6 n15 VDD VDD sg13_lv_pmos w=9.8e-07 l=1.3e-07 ng=1
MN17 n15 n0 n20 VSS sg13_lv_nmos w=1.5e-07 l=1.3e-07 ng=1
MN18 n20 n6 VSS VSS sg13_lv_nmos w=1.5e-07 l=1.3e-07 ng=1
MP17 n15 n1 n21 VDD sg13_lv_pmos w=1.5e-07 l=1.3e-07 ng=1
MP18 n21 n6 VDD VDD sg13_lv_pmos w=1.5e-07 l=1.3e-07 ng=1
MN19 Q n15 VSS VSS sg13_lv_nmos w=1.07e-06 l=1.3e-07 ng=1
MP19 Q n15 VDD VDD sg13_lv_pmos w=1.6e-06 l=1.3e-07 ng=1
MN20 QN n6 VSS VSS sg13_lv_nmos w=1.07e-06 l=1.3e-07 ng=1
MP20 QN n6 VDD VDD sg13_lv_pmos w=1.6e-06 l=1.3e-07 ng=1
.ENDS

****************************************
* Cell : DFESQQN_DL
* Description : D flip-flop with enable, synchronous set and outputs Q and QN.
* ┌───────┬─────┬─────┬─────┬─────┬──────┬────────────────┐
* │ CLK   │ D   │ E   │   S │ Q   │ QN   │ Description    │
* ├───────┼─────┼─────┼─────┼─────┼──────┼────────────────┤
* │ R     │ 0   │ 1   │   0 │ 0   │ 1    │ Write 0        │
* ├───────┼─────┼─────┼─────┼─────┼──────┼────────────────┤
* │ R     │ 1   │ 1   │   0 │ 1   │ 0    │ Write 1        │
* ├───────┼─────┼─────┼─────┼─────┼──────┼────────────────┤
* │ R     │ -   │ 0   │   0 │ Q   │ QN   │ Write disabled │
* ├───────┼─────┼─────┼─────┼─────┼──────┼────────────────┤
* │ R     │ -   │ -   │   1 │ 1   │ 0    │ Set            │
* └───────┴─────┴─────┴─────┴─────┴──────┴────────────────┘
****************************************
.SUBCKT DFESQQN_DL D E S CLK Q QN VDD VSS
*.PININFO CLK:I D:I E:I S:I Q:O QN:O VDD:B VSS:B
MN0 n0 CLK VSS VSS sg13_lv_nmos w=3e-07 l=1.3e-07 ng=1
MP0 n0 CLK VDD VDD sg13_lv_pmos w=4.5e-07 l=1.3e-07 ng=1
MN1 n1 n0 VSS VSS sg13_lv_nmos w=1.5e-07 l=1.3e-07 ng=1
MP1 n1 n0 VDD VDD sg13_lv_pmos w=2.5e-07 l=1.3e-07 ng=1
MN2 n2 E VSS VSS sg13_lv_nmos w=1.5e-07 l=1.3e-07 ng=1
MP2 n2 E VDD VDD sg13_lv_pmos w=2.3e-07 l=1.3e-07 ng=1
MN3 n3 S VSS VSS sg13_lv_nmos w=1.5e-07 l=1.3e-07
MN4 n4 E VSS VSS sg13_lv_nmos w=1.5e-07 l=1.3e-07
MN5 n3 D n4 VSS sg13_lv_nmos w=1.5e-07 l=1.3e-07
MN6 n5 n2 VSS VSS sg13_lv_nmos w=1.5e-07 l=1.3e-07
MN7 n3 n6 n5 VSS sg13_lv_nmos w=1.5e-07 l=1.3e-07
MN8 n7 n0 n3 VSS sg13_lv_nmos w=1.5e-07 l=1.3e-07
MP3 n8 S VDD VDD sg13_lv_pmos w=2e-07 l=1.3e-07
MP4 n9 E n8 VDD sg13_lv_pmos w=2e-07 l=1.3e-07
MP5 n10 n6 n9 VDD sg13_lv_pmos w=2e-07 l=1.3e-07
MP6 n11 n2 n8 VDD sg13_lv_pmos w=2e-07 l=1.3e-07
MP7 n10 D n11 VDD sg13_lv_pmos w=2e-07 l=1.3e-07
MP8 n7 n1 n10 VDD sg13_lv_pmos w=2e-07 l=1.3e-07
MN9 n12 n7 VSS VSS sg13_lv_nmos w=2e-07 l=1.3e-07 ng=1
MP9 n12 n7 VDD VDD sg13_lv_pmos w=4e-07 l=1.3e-07 ng=1
MN10 n7 n1 n13 VSS sg13_lv_nmos w=1.5e-07 l=1.3e-07 ng=1
MN11 n13 n12 VSS VSS sg13_lv_nmos w=1.5e-07 l=1.3e-07 ng=1
MP10 n7 n0 n14 VDD sg13_lv_pmos w=3e-07 l=1.3e-07 ng=1
MP11 n14 n12 VDD VDD sg13_lv_pmos w=3e-07 l=1.3e-07 ng=1
MN12 n15 n1 n16 VSS sg13_lv_nmos w=6e-07 l=1.3e-07 ng=1
MN13 n16 n12 VSS VSS sg13_lv_nmos w=6e-07 l=1.3e-07 ng=1
MP12 n15 n0 n17 VDD sg13_lv_pmos w=9e-07 l=1.3e-07 ng=1
MP13 n17 n12 VDD VDD sg13_lv_pmos w=9e-07 l=1.3e-07 ng=1
MN14 n6 n15 VSS VSS sg13_lv_nmos w=3e-07 l=1.3e-07 ng=1
MP14 n6 n15 VDD VDD sg13_lv_pmos w=5e-07 l=1.3e-07 ng=1
MN15 n15 n0 n18 VSS sg13_lv_nmos w=1.5e-07 l=1.3e-07 ng=1
MN16 n18 n6 VSS VSS sg13_lv_nmos w=1.5e-07 l=1.3e-07 ng=1
MP15 n15 n1 n19 VDD sg13_lv_pmos w=1.5e-07 l=1.3e-07 ng=1
MP16 n19 n6 VDD VDD sg13_lv_pmos w=1.5e-07 l=1.3e-07 ng=1
MN17 Q n15 VSS VSS sg13_lv_nmos w=3.2e-07 l=1.3e-07 ng=1
MP17 Q n15 VDD VDD sg13_lv_pmos w=4.9e-07 l=1.3e-07 ng=1
MN18 QN n6 VSS VSS sg13_lv_nmos w=3.2e-07 l=1.3e-07 ng=1
MP18 QN n6 VDD VDD sg13_lv_pmos w=4.9e-07 l=1.3e-07 ng=1
.ENDS

****************************************
* Cell : DFESQ_D1
* Description : D flip-flop with enable, synchronous set and output Q.
* ┌───────┬─────┬─────┬─────┬─────┬────────────────┐
* │ CLK   │ D   │ E   │   S │ Q   │ Description    │
* ├───────┼─────┼─────┼─────┼─────┼────────────────┤
* │ R     │ 0   │ 1   │   0 │ 0   │ Write 0        │
* ├───────┼─────┼─────┼─────┼─────┼────────────────┤
* │ R     │ 1   │ 1   │   0 │ 1   │ Write 1        │
* ├───────┼─────┼─────┼─────┼─────┼────────────────┤
* │ R     │ -   │ 0   │   0 │ Q   │ Write disabled │
* ├───────┼─────┼─────┼─────┼─────┼────────────────┤
* │ R     │ -   │ -   │   1 │ 1   │ Set            │
* └───────┴─────┴─────┴─────┴─────┴────────────────┘
****************************************
.SUBCKT DFESQ_D1 D E S CLK Q VDD VSS
*.PININFO CLK:I D:I E:I S:I Q:O VDD:B VSS:B
MN0 n0 CLK VSS VSS sg13_lv_nmos w=3e-07 l=1.3e-07 ng=1
MP0 n0 CLK VDD VDD sg13_lv_pmos w=4.5e-07 l=1.3e-07 ng=1
MN1 n1 n0 VSS VSS sg13_lv_nmos w=1.5e-07 l=1.3e-07 ng=1
MP1 n1 n0 VDD VDD sg13_lv_pmos w=2.5e-07 l=1.3e-07 ng=1
MN2 n2 E VSS VSS sg13_lv_nmos w=1.5e-07 l=1.3e-07 ng=1
MP2 n2 E VDD VDD sg13_lv_pmos w=2.3e-07 l=1.3e-07 ng=1
MN3 n3 S VSS VSS sg13_lv_nmos w=1.5e-07 l=1.3e-07
MN4 n4 E VSS VSS sg13_lv_nmos w=1.5e-07 l=1.3e-07
MN5 n3 D n4 VSS sg13_lv_nmos w=1.5e-07 l=1.3e-07
MN6 n5 n2 VSS VSS sg13_lv_nmos w=1.5e-07 l=1.3e-07
MN7 n3 n6 n5 VSS sg13_lv_nmos w=1.5e-07 l=1.3e-07
MN8 n7 n0 n3 VSS sg13_lv_nmos w=1.5e-07 l=1.3e-07
MP3 n8 S VDD VDD sg13_lv_pmos w=2e-07 l=1.3e-07
MP4 n9 E n8 VDD sg13_lv_pmos w=2e-07 l=1.3e-07
MP5 n10 n6 n9 VDD sg13_lv_pmos w=2e-07 l=1.3e-07
MP6 n11 n2 n8 VDD sg13_lv_pmos w=2e-07 l=1.3e-07
MP7 n10 D n11 VDD sg13_lv_pmos w=2e-07 l=1.3e-07
MP8 n7 n1 n10 VDD sg13_lv_pmos w=2e-07 l=1.3e-07
MN9 n12 n7 VSS VSS sg13_lv_nmos w=2e-07 l=1.3e-07 ng=1
MP9 n12 n7 VDD VDD sg13_lv_pmos w=4e-07 l=1.3e-07 ng=1
MN10 n7 n1 n13 VSS sg13_lv_nmos w=1.5e-07 l=1.3e-07 ng=1
MN11 n13 n12 VSS VSS sg13_lv_nmos w=1.5e-07 l=1.3e-07 ng=1
MP10 n7 n0 n14 VDD sg13_lv_pmos w=3e-07 l=1.3e-07 ng=1
MP11 n14 n12 VDD VDD sg13_lv_pmos w=3e-07 l=1.3e-07 ng=1
MN12 n15 n1 n16 VSS sg13_lv_nmos w=6e-07 l=1.3e-07 ng=1
MN13 n16 n12 VSS VSS sg13_lv_nmos w=6e-07 l=1.3e-07 ng=1
MP12 n15 n0 n17 VDD sg13_lv_pmos w=9e-07 l=1.3e-07 ng=1
MP13 n17 n12 VDD VDD sg13_lv_pmos w=9e-07 l=1.3e-07 ng=1
MN14 n6 n15 VSS VSS sg13_lv_nmos w=3e-07 l=1.3e-07 ng=1
MP14 n6 n15 VDD VDD sg13_lv_pmos w=5e-07 l=1.3e-07 ng=1
MN15 n15 n0 n18 VSS sg13_lv_nmos w=1.5e-07 l=1.3e-07 ng=1
MN16 n18 n6 VSS VSS sg13_lv_nmos w=1.5e-07 l=1.3e-07 ng=1
MP15 n15 n1 n19 VDD sg13_lv_pmos w=1.5e-07 l=1.3e-07 ng=1
MP16 n19 n6 VDD VDD sg13_lv_pmos w=1.5e-07 l=1.3e-07 ng=1
MN17 Q n15 VSS VSS sg13_lv_nmos w=6.4e-07 l=1.3e-07 ng=1
MP17 Q n15 VDD VDD sg13_lv_pmos w=9.8e-07 l=1.3e-07 ng=1
.ENDS

****************************************
* Cell : DFESQ_D2
* Description : D flip-flop with enable, synchronous set and output Q.
* ┌───────┬─────┬─────┬─────┬─────┬────────────────┐
* │ CLK   │ D   │ E   │   S │ Q   │ Description    │
* ├───────┼─────┼─────┼─────┼─────┼────────────────┤
* │ R     │ 0   │ 1   │   0 │ 0   │ Write 0        │
* ├───────┼─────┼─────┼─────┼─────┼────────────────┤
* │ R     │ 1   │ 1   │   0 │ 1   │ Write 1        │
* ├───────┼─────┼─────┼─────┼─────┼────────────────┤
* │ R     │ -   │ 0   │   0 │ Q   │ Write disabled │
* ├───────┼─────┼─────┼─────┼─────┼────────────────┤
* │ R     │ -   │ -   │   1 │ 1   │ Set            │
* └───────┴─────┴─────┴─────┴─────┴────────────────┘
****************************************
.SUBCKT DFESQ_D2 D E S CLK Q VDD VSS
*.PININFO CLK:I D:I E:I S:I Q:O VDD:B VSS:B
MN0 n0 CLK VSS VSS sg13_lv_nmos w=6.4e-07 l=1.3e-07 ng=1
MP0 n0 CLK VDD VDD sg13_lv_pmos w=9.8e-07 l=1.3e-07 ng=1
MN1 n1 n0 VSS VSS sg13_lv_nmos w=3e-07 l=1.3e-07 ng=1
MP1 n1 n0 VDD VDD sg13_lv_pmos w=5e-07 l=1.3e-07 ng=1
MN2 n2 E VSS VSS sg13_lv_nmos w=1.5e-07 l=1.3e-07 ng=1
MP2 n2 E VDD VDD sg13_lv_pmos w=3e-07 l=1.3e-07 ng=1
MN3 n3 S VSS VSS sg13_lv_nmos w=3e-07 l=1.3e-07
MN4 n4 E VSS VSS sg13_lv_nmos w=3e-07 l=1.3e-07
MN5 n3 D n4 VSS sg13_lv_nmos w=3e-07 l=1.3e-07
MN6 n5 n2 VSS VSS sg13_lv_nmos w=3e-07 l=1.3e-07
MN7 n3 n6 n5 VSS sg13_lv_nmos w=3e-07 l=1.3e-07
MN8 n7 n0 n3 VSS sg13_lv_nmos w=3e-07 l=1.3e-07
MP3 n8 S VDD VDD sg13_lv_pmos w=4.2e-07 l=1.3e-07
MP4 n9 E n8 VDD sg13_lv_pmos w=4.2e-07 l=1.3e-07
MP5 n10 n6 n9 VDD sg13_lv_pmos w=4.2e-07 l=1.3e-07
MP6 n11 n2 n8 VDD sg13_lv_pmos w=4.2e-07 l=1.3e-07
MP7 n10 D n11 VDD sg13_lv_pmos w=4.2e-07 l=1.3e-07
MP8 n7 n1 n10 VDD sg13_lv_pmos w=4.2e-07 l=1.3e-07
MN9 n12 n7 VSS VSS sg13_lv_nmos w=4e-07 l=1.3e-07 ng=1
MP9 n12 n7 VDD VDD sg13_lv_pmos w=6e-07 l=1.3e-07 ng=1
MN10 n7 n1 n13 VSS sg13_lv_nmos w=1.5e-07 l=1.3e-07 ng=1
MN11 n13 n12 VSS VSS sg13_lv_nmos w=1.5e-07 l=1.3e-07 ng=1
MP10 n7 n0 n14 VDD sg13_lv_pmos w=2.3e-07 l=1.3e-07 ng=1
MP11 n14 n12 VDD VDD sg13_lv_pmos w=2.3e-07 l=1.3e-07 ng=1
MN12 n15 n1 n16 VSS sg13_lv_nmos w=6.4e-07 l=1.3e-07 ng=1
MN13 n16 n12 VSS VSS sg13_lv_nmos w=6.4e-07 l=1.3e-07 ng=1
MP12 n15 n0 n17 VDD sg13_lv_pmos w=9.8e-07 l=1.3e-07 ng=1
MP13 n17 n12 VDD VDD sg13_lv_pmos w=9.8e-07 l=1.3e-07 ng=1
MN14 n15 n1 n18 VSS sg13_lv_nmos w=6.4e-07 l=1.3e-07 ng=1
MN15 n18 n12 VSS VSS sg13_lv_nmos w=6.4e-07 l=1.3e-07 ng=1
MP14 n15 n0 n19 VDD sg13_lv_pmos w=9.8e-07 l=1.3e-07 ng=1
MP15 n19 n12 VDD VDD sg13_lv_pmos w=9.8e-07 l=1.3e-07 ng=1
MN16 n6 n15 VSS VSS sg13_lv_nmos w=6.4e-07 l=1.3e-07 ng=1
MP16 n6 n15 VDD VDD sg13_lv_pmos w=9.8e-07 l=1.3e-07 ng=1
MN17 n15 n0 n20 VSS sg13_lv_nmos w=1.5e-07 l=1.3e-07 ng=1
MN18 n20 n6 VSS VSS sg13_lv_nmos w=1.5e-07 l=1.3e-07 ng=1
MP17 n15 n1 n21 VDD sg13_lv_pmos w=1.5e-07 l=1.3e-07 ng=1
MP18 n21 n6 VDD VDD sg13_lv_pmos w=1.5e-07 l=1.3e-07 ng=1
MN19 Q n15 VSS VSS sg13_lv_nmos w=1.07e-06 l=1.3e-07 ng=1
MP19 Q n15 VDD VDD sg13_lv_pmos w=1.6e-06 l=1.3e-07 ng=1
.ENDS

****************************************
* Cell : DFESQ_DL
* Description : D flip-flop with enable, synchronous set and output Q.
* ┌───────┬─────┬─────┬─────┬─────┬────────────────┐
* │ CLK   │ D   │ E   │   S │ Q   │ Description    │
* ├───────┼─────┼─────┼─────┼─────┼────────────────┤
* │ R     │ 0   │ 1   │   0 │ 0   │ Write 0        │
* ├───────┼─────┼─────┼─────┼─────┼────────────────┤
* │ R     │ 1   │ 1   │   0 │ 1   │ Write 1        │
* ├───────┼─────┼─────┼─────┼─────┼────────────────┤
* │ R     │ -   │ 0   │   0 │ Q   │ Write disabled │
* ├───────┼─────┼─────┼─────┼─────┼────────────────┤
* │ R     │ -   │ -   │   1 │ 1   │ Set            │
* └───────┴─────┴─────┴─────┴─────┴────────────────┘
****************************************
.SUBCKT DFESQ_DL D E S CLK Q VDD VSS
*.PININFO CLK:I D:I E:I S:I Q:O VDD:B VSS:B
MN0 n0 CLK VSS VSS sg13_lv_nmos w=3e-07 l=1.3e-07 ng=1
MP0 n0 CLK VDD VDD sg13_lv_pmos w=4.5e-07 l=1.3e-07 ng=1
MN1 n1 n0 VSS VSS sg13_lv_nmos w=1.5e-07 l=1.3e-07 ng=1
MP1 n1 n0 VDD VDD sg13_lv_pmos w=2.5e-07 l=1.3e-07 ng=1
MN2 n2 E VSS VSS sg13_lv_nmos w=1.5e-07 l=1.3e-07 ng=1
MP2 n2 E VDD VDD sg13_lv_pmos w=2.3e-07 l=1.3e-07 ng=1
MN3 n3 S VSS VSS sg13_lv_nmos w=1.5e-07 l=1.3e-07
MN4 n4 E VSS VSS sg13_lv_nmos w=1.5e-07 l=1.3e-07
MN5 n3 D n4 VSS sg13_lv_nmos w=1.5e-07 l=1.3e-07
MN6 n5 n2 VSS VSS sg13_lv_nmos w=1.5e-07 l=1.3e-07
MN7 n3 n6 n5 VSS sg13_lv_nmos w=1.5e-07 l=1.3e-07
MN8 n7 n0 n3 VSS sg13_lv_nmos w=1.5e-07 l=1.3e-07
MP3 n8 S VDD VDD sg13_lv_pmos w=2e-07 l=1.3e-07
MP4 n9 E n8 VDD sg13_lv_pmos w=2e-07 l=1.3e-07
MP5 n10 n6 n9 VDD sg13_lv_pmos w=2e-07 l=1.3e-07
MP6 n11 n2 n8 VDD sg13_lv_pmos w=2e-07 l=1.3e-07
MP7 n10 D n11 VDD sg13_lv_pmos w=2e-07 l=1.3e-07
MP8 n7 n1 n10 VDD sg13_lv_pmos w=2e-07 l=1.3e-07
MN9 n12 n7 VSS VSS sg13_lv_nmos w=2e-07 l=1.3e-07 ng=1
MP9 n12 n7 VDD VDD sg13_lv_pmos w=4e-07 l=1.3e-07 ng=1
MN10 n7 n1 n13 VSS sg13_lv_nmos w=1.5e-07 l=1.3e-07 ng=1
MN11 n13 n12 VSS VSS sg13_lv_nmos w=1.5e-07 l=1.3e-07 ng=1
MP10 n7 n0 n14 VDD sg13_lv_pmos w=3e-07 l=1.3e-07 ng=1
MP11 n14 n12 VDD VDD sg13_lv_pmos w=3e-07 l=1.3e-07 ng=1
MN12 n15 n1 n16 VSS sg13_lv_nmos w=6e-07 l=1.3e-07 ng=1
MN13 n16 n12 VSS VSS sg13_lv_nmos w=6e-07 l=1.3e-07 ng=1
MP12 n15 n0 n17 VDD sg13_lv_pmos w=9e-07 l=1.3e-07 ng=1
MP13 n17 n12 VDD VDD sg13_lv_pmos w=9e-07 l=1.3e-07 ng=1
MN14 n6 n15 VSS VSS sg13_lv_nmos w=3e-07 l=1.3e-07 ng=1
MP14 n6 n15 VDD VDD sg13_lv_pmos w=5e-07 l=1.3e-07 ng=1
MN15 n15 n0 n18 VSS sg13_lv_nmos w=1.5e-07 l=1.3e-07 ng=1
MN16 n18 n6 VSS VSS sg13_lv_nmos w=1.5e-07 l=1.3e-07 ng=1
MP15 n15 n1 n19 VDD sg13_lv_pmos w=1.5e-07 l=1.3e-07 ng=1
MP16 n19 n6 VDD VDD sg13_lv_pmos w=1.5e-07 l=1.3e-07 ng=1
MN17 Q n15 VSS VSS sg13_lv_nmos w=3.2e-07 l=1.3e-07 ng=1
MP17 Q n15 VDD VDD sg13_lv_pmos w=4.9e-07 l=1.3e-07 ng=1
.ENDS

****************************************
* Cell : DFQN_D1
* Description : D flip-flop with output QN.
* ┌───────┬─────┬──────┬───────────────┐
* │ CLK   │   D │   QN │ Description   │
* ├───────┼─────┼──────┼───────────────┤
* │ R     │   0 │    1 │ Write 0       │
* ├───────┼─────┼──────┼───────────────┤
* │ R     │   1 │    0 │ Write 1       │
* └───────┴─────┴──────┴───────────────┘
****************************************
.SUBCKT DFQN_D1 D CLK QN VDD VSS
*.PININFO CLK:I D:I QN:O VDD:B VSS:B
MN0 n0 CLK VSS VSS sg13_lv_nmos w=3e-07 l=1.3e-07 ng=1
MP0 n0 CLK VDD VDD sg13_lv_pmos w=4.5e-07 l=1.3e-07 ng=1
MN1 n1 n0 VSS VSS sg13_lv_nmos w=2e-07 l=1.3e-07 ng=1
MP1 n1 n0 VDD VDD sg13_lv_pmos w=3e-07 l=1.3e-07 ng=1
MN2 n2 D n3 VSS sg13_lv_nmos w=1.5e-07 l=1.3e-07 ng=1
MN3 n3 n0 VSS VSS sg13_lv_nmos w=1.5e-07 l=1.3e-07 ng=1
MP2 n2 D n4 VDD sg13_lv_pmos w=2.3e-07 l=1.3e-07 ng=1
MP3 n4 n1 VDD VDD sg13_lv_pmos w=2.3e-07 l=1.3e-07 ng=1
MN4 n5 n2 VSS VSS sg13_lv_nmos w=2e-07 l=1.3e-07 ng=1
MP4 n5 n2 VDD VDD sg13_lv_pmos w=3e-07 l=1.3e-07 ng=1
MN5 n2 n1 n6 VSS sg13_lv_nmos w=1.5e-07 l=1.3e-07 ng=1
MN6 n6 n5 VSS VSS sg13_lv_nmos w=1.5e-07 l=1.3e-07 ng=1
MP5 n2 n0 n7 VDD sg13_lv_pmos w=2.3e-07 l=1.3e-07 ng=1
MP6 n7 n5 VDD VDD sg13_lv_pmos w=2.3e-07 l=1.3e-07 ng=1
MN7 n8 n1 n9 VSS sg13_lv_nmos w=5e-07 l=1.3e-07 ng=1
MN8 n9 n5 VSS VSS sg13_lv_nmos w=5e-07 l=1.3e-07 ng=1
MP7 n8 n0 n10 VDD sg13_lv_pmos w=7.5e-07 l=1.3e-07 ng=1
MP8 n10 n5 VDD VDD sg13_lv_pmos w=7.5e-07 l=1.3e-07 ng=1
MN9 n11 n8 VSS VSS sg13_lv_nmos w=3e-07 l=1.3e-07 ng=1
MP9 n11 n8 VDD VDD sg13_lv_pmos w=4.5e-07 l=1.3e-07 ng=1
MN10 n8 n0 n12 VSS sg13_lv_nmos w=1.5e-07 l=1.3e-07 ng=1
MN11 n12 n11 VSS VSS sg13_lv_nmos w=1.5e-07 l=1.3e-07 ng=1
MP10 n8 n1 n13 VDD sg13_lv_pmos w=1.5e-07 l=1.3e-07 ng=1
MP11 n13 n11 VDD VDD sg13_lv_pmos w=1.5e-07 l=1.3e-07 ng=1
MN12 QN n11 VSS VSS sg13_lv_nmos w=6.4e-07 l=1.3e-07 ng=1
MP12 QN n11 VDD VDD sg13_lv_pmos w=9.8e-07 l=1.3e-07 ng=1
.ENDS

****************************************
* Cell : DFQN_D2
* Description : D flip-flop with output QN.
* ┌───────┬─────┬──────┬───────────────┐
* │ CLK   │   D │   QN │ Description   │
* ├───────┼─────┼──────┼───────────────┤
* │ R     │   0 │    1 │ Write 0       │
* ├───────┼─────┼──────┼───────────────┤
* │ R     │   1 │    0 │ Write 1       │
* └───────┴─────┴──────┴───────────────┘
****************************************
.SUBCKT DFQN_D2 D CLK QN VDD VSS
*.PININFO CLK:I D:I QN:O VDD:B VSS:B
MN0 n0 CLK VSS VSS sg13_lv_nmos w=4e-07 l=1.3e-07 ng=1
MP0 n0 CLK VDD VDD sg13_lv_pmos w=6e-07 l=1.3e-07 ng=1
MN1 n1 n0 VSS VSS sg13_lv_nmos w=3e-07 l=1.3e-07 ng=1
MP1 n1 n0 VDD VDD sg13_lv_pmos w=4.5e-07 l=1.3e-07 ng=1
MN2 n2 n0 n3 VSS sg13_lv_nmos w=2.5e-07 l=1.3e-07 ng=1
MN3 n3 D VSS VSS sg13_lv_nmos w=2.5e-07 l=1.3e-07 ng=1
MP2 n2 n1 n4 VDD sg13_lv_pmos w=3.8e-07 l=1.3e-07 ng=1
MP3 n4 D VDD VDD sg13_lv_pmos w=3.8e-07 l=1.3e-07 ng=1
MN4 n5 n2 VSS VSS sg13_lv_nmos w=3e-07 l=1.3e-07 ng=1
MP4 n5 n2 VDD VDD sg13_lv_pmos w=4.5e-07 l=1.3e-07 ng=1
MN5 n2 n1 n6 VSS sg13_lv_nmos w=1.5e-07 l=1.3e-07 ng=1
MN6 n6 n5 VSS VSS sg13_lv_nmos w=1.5e-07 l=1.3e-07 ng=1
MP5 n2 n0 n7 VDD sg13_lv_pmos w=2.3e-07 l=1.3e-07 ng=1
MP6 n7 n5 VDD VDD sg13_lv_pmos w=2.3e-07 l=1.3e-07 ng=1
MN7 n8 n1 n9 VSS sg13_lv_nmos w=9.2e-07 l=1.3e-07 ng=1
MN8 n9 n5 VSS VSS sg13_lv_nmos w=9.2e-07 l=1.3e-07 ng=1
MP7 n8 n0 n10 VDD sg13_lv_pmos w=1.38e-06 l=1.3e-07 ng=1
MP8 n10 n5 VDD VDD sg13_lv_pmos w=1.38e-06 l=1.3e-07 ng=1
MN9 n11 n8 VSS VSS sg13_lv_nmos w=5e-07 l=1.3e-07 ng=1
MP9 n11 n8 VDD VDD sg13_lv_pmos w=7.5e-07 l=1.3e-07 ng=1
MN10 n8 n0 n12 VSS sg13_lv_nmos w=1.5e-07 l=1.3e-07 ng=1
MN11 n12 n11 VSS VSS sg13_lv_nmos w=1.5e-07 l=1.3e-07 ng=1
MP10 n8 n1 n13 VDD sg13_lv_pmos w=1.5e-07 l=1.3e-07 ng=1
MP11 n13 n11 VDD VDD sg13_lv_pmos w=1.5e-07 l=1.3e-07 ng=1
MN12 QN n11 VSS VSS sg13_lv_nmos w=1.07e-06 l=1.3e-07 ng=1
MP12 QN n11 VDD VDD sg13_lv_pmos w=1.6e-06 l=1.3e-07 ng=1
.ENDS

****************************************
* Cell : DFQN_D4
* Description : D flip-flop with output QN.
* ┌───────┬─────┬──────┬───────────────┐
* │ CLK   │   D │   QN │ Description   │
* ├───────┼─────┼──────┼───────────────┤
* │ R     │   0 │    1 │ Write 0       │
* ├───────┼─────┼──────┼───────────────┤
* │ R     │   1 │    0 │ Write 1       │
* └───────┴─────┴──────┴───────────────┘
****************************************
.SUBCKT DFQN_D4 D CLK QN VDD VSS
*.PININFO CLK:I D:I QN:O VDD:B VSS:B
MN0 n0 CLK VSS VSS sg13_lv_nmos w=7.5e-07 l=1.3e-07 ng=1
MP0 n0 CLK VDD VDD sg13_lv_pmos w=1.12e-06 l=1.3e-07 ng=1
MN1 n1 n0 VSS VSS sg13_lv_nmos w=5.5e-07 l=1.3e-07 ng=1
MP1 n1 n0 VDD VDD sg13_lv_pmos w=8.3e-07 l=1.3e-07 ng=1
MN2 n2 n0 n3 VSS sg13_lv_nmos w=4e-07 l=1.3e-07 ng=1
MN3 n3 D VSS VSS sg13_lv_nmos w=4e-07 l=1.3e-07 ng=1
MP2 n2 n1 n4 VDD sg13_lv_pmos w=6e-07 l=1.3e-07 ng=1
MP3 n4 D VDD VDD sg13_lv_pmos w=6e-07 l=1.3e-07 ng=1
MN4 n5 n2 VSS VSS sg13_lv_nmos w=6.5e-07 l=1.3e-07 ng=1
MP4 n5 n2 VDD VDD sg13_lv_pmos w=9.8e-07 l=1.3e-07 ng=1
MN5 n2 n1 n6 VSS sg13_lv_nmos w=1.5e-07 l=1.3e-07 ng=1
MN6 n6 n5 VSS VSS sg13_lv_nmos w=1.5e-07 l=1.3e-07 ng=1
MP5 n2 n0 n7 VDD sg13_lv_pmos w=2.3e-07 l=1.3e-07 ng=1
MP6 n7 n5 VDD VDD sg13_lv_pmos w=2.3e-07 l=1.3e-07 ng=1
MN7 n8 n1 n9 VSS sg13_lv_nmos w=2e-06 l=1.3e-07 ng=2
MN8 n9 n5 VSS VSS sg13_lv_nmos w=2e-06 l=1.3e-07 ng=2
MP7 n8 n0 n10 VDD sg13_lv_pmos w=3e-06 l=1.3e-07 ng=2
MP8 n10 n5 VDD VDD sg13_lv_pmos w=3e-06 l=1.3e-07 ng=2
MN9 n11 n8 VSS VSS sg13_lv_nmos w=8.5e-07 l=1.3e-07 ng=1
MP9 n11 n8 VDD VDD sg13_lv_pmos w=1.28e-06 l=1.3e-07 ng=1
MN10 n8 n0 n12 VSS sg13_lv_nmos w=1.5e-07 l=1.3e-07 ng=1
MN11 n12 n11 VSS VSS sg13_lv_nmos w=1.5e-07 l=1.3e-07 ng=1
MP10 n8 n1 n13 VDD sg13_lv_pmos w=1.5e-07 l=1.3e-07 ng=1
MP11 n13 n11 VDD VDD sg13_lv_pmos w=1.5e-07 l=1.3e-07 ng=1
MN12 QN n11 VSS VSS sg13_lv_nmos w=2.14e-06 l=1.3e-07 ng=3
MP12 QN n11 VDD VDD sg13_lv_pmos w=3.2e-06 l=1.3e-07 ng=3
.ENDS

****************************************
* Cell : DFQN_DL
* Description : D flip-flop with output QN.
* ┌───────┬─────┬──────┬───────────────┐
* │ CLK   │   D │   QN │ Description   │
* ├───────┼─────┼──────┼───────────────┤
* │ R     │   0 │    1 │ Write 0       │
* ├───────┼─────┼──────┼───────────────┤
* │ R     │   1 │    0 │ Write 1       │
* └───────┴─────┴──────┴───────────────┘
****************************************
.SUBCKT DFQN_DL D CLK QN VDD VSS
*.PININFO CLK:I D:I QN:O VDD:B VSS:B
MN0 n0 CLK VSS VSS sg13_lv_nmos w=2e-07 l=1.3e-07 ng=1
MP0 n0 CLK VDD VDD sg13_lv_pmos w=3e-07 l=1.3e-07 ng=1
MN1 n1 n0 VSS VSS sg13_lv_nmos w=2e-07 l=1.3e-07 ng=1
MP1 n1 n0 VDD VDD sg13_lv_pmos w=3e-07 l=1.3e-07 ng=1
MN2 n2 D n3 VSS sg13_lv_nmos w=1.5e-07 l=1.3e-07 ng=1
MN3 n3 n0 VSS VSS sg13_lv_nmos w=1.5e-07 l=1.3e-07 ng=1
MP2 n2 D n4 VDD sg13_lv_pmos w=2.3e-07 l=1.3e-07 ng=1
MP3 n4 n1 VDD VDD sg13_lv_pmos w=2.3e-07 l=1.3e-07 ng=1
MN4 n5 n2 VSS VSS sg13_lv_nmos w=1.5e-07 l=1.3e-07 ng=1
MP4 n5 n2 VDD VDD sg13_lv_pmos w=2.3e-07 l=1.3e-07 ng=1
MN5 n2 n1 n6 VSS sg13_lv_nmos w=1.5e-07 l=1.3e-07 ng=1
MN6 n6 n5 VSS VSS sg13_lv_nmos w=1.5e-07 l=1.3e-07 ng=1
MP5 n2 n0 n7 VDD sg13_lv_pmos w=2.3e-07 l=1.3e-07 ng=1
MP6 n7 n5 VDD VDD sg13_lv_pmos w=2.3e-07 l=1.3e-07 ng=1
MN7 n8 n1 n9 VSS sg13_lv_nmos w=2e-07 l=1.3e-07 ng=1
MN8 n9 n5 VSS VSS sg13_lv_nmos w=2e-07 l=1.3e-07 ng=1
MP7 n8 n0 n10 VDD sg13_lv_pmos w=3e-07 l=1.3e-07 ng=1
MP8 n10 n5 VDD VDD sg13_lv_pmos w=3e-07 l=1.3e-07 ng=1
MN9 n11 n8 VSS VSS sg13_lv_nmos w=1.5e-07 l=1.3e-07 ng=1
MP9 n11 n8 VDD VDD sg13_lv_pmos w=2.3e-07 l=1.3e-07 ng=1
MN10 n8 n0 n12 VSS sg13_lv_nmos w=1.5e-07 l=1.3e-07 ng=1
MN11 n12 n11 VSS VSS sg13_lv_nmos w=1.5e-07 l=1.3e-07 ng=1
MP10 n8 n1 n13 VDD sg13_lv_pmos w=1.5e-07 l=1.3e-07 ng=1
MP11 n13 n11 VDD VDD sg13_lv_pmos w=1.5e-07 l=1.3e-07 ng=1
MN12 QN n11 VSS VSS sg13_lv_nmos w=3.2e-07 l=1.3e-07 ng=1
MP12 QN n11 VDD VDD sg13_lv_pmos w=4.9e-07 l=1.3e-07 ng=1
.ENDS

****************************************
* Cell : DFQQN_D1
* Description : D flip-flop with outputs Q and QN.
* ┌───────┬─────┬─────┬──────┬───────────────┐
* │ CLK   │   D │   Q │   QN │ Description   │
* ├───────┼─────┼─────┼──────┼───────────────┤
* │ R     │   0 │   0 │    1 │ Write 0       │
* ├───────┼─────┼─────┼──────┼───────────────┤
* │ R     │   1 │   1 │    0 │ Write 1       │
* └───────┴─────┴─────┴──────┴───────────────┘
****************************************
.SUBCKT DFQQN_D1 D CLK Q QN VDD VSS
*.PININFO CLK:I D:I Q:O QN:O VDD:B VSS:B
MN0 n0 CLK VSS VSS sg13_lv_nmos w=3e-07 l=1.3e-07 ng=1
MP0 n0 CLK VDD VDD sg13_lv_pmos w=4.5e-07 l=1.3e-07 ng=1
MN1 n1 n0 VSS VSS sg13_lv_nmos w=2e-07 l=1.3e-07 ng=1
MP1 n1 n0 VDD VDD sg13_lv_pmos w=3e-07 l=1.3e-07 ng=1
MN2 n2 D n3 VSS sg13_lv_nmos w=1.5e-07 l=1.3e-07 ng=1
MN3 n3 n0 VSS VSS sg13_lv_nmos w=1.5e-07 l=1.3e-07 ng=1
MP2 n2 D n4 VDD sg13_lv_pmos w=2.3e-07 l=1.3e-07 ng=1
MP3 n4 n1 VDD VDD sg13_lv_pmos w=2.3e-07 l=1.3e-07 ng=1
MN4 n5 n2 VSS VSS sg13_lv_nmos w=2e-07 l=1.3e-07 ng=1
MP4 n5 n2 VDD VDD sg13_lv_pmos w=3e-07 l=1.3e-07 ng=1
MN5 n2 n1 n6 VSS sg13_lv_nmos w=1.5e-07 l=1.3e-07 ng=1
MN6 n6 n5 VSS VSS sg13_lv_nmos w=1.5e-07 l=1.3e-07 ng=1
MP5 n2 n0 n7 VDD sg13_lv_pmos w=2.3e-07 l=1.3e-07 ng=1
MP6 n7 n5 VDD VDD sg13_lv_pmos w=2.3e-07 l=1.3e-07 ng=1
MN7 n8 n1 n9 VSS sg13_lv_nmos w=5e-07 l=1.3e-07 ng=1
MN8 n9 n5 VSS VSS sg13_lv_nmos w=5e-07 l=1.3e-07 ng=1
MP7 n8 n0 n10 VDD sg13_lv_pmos w=7.5e-07 l=1.3e-07 ng=1
MP8 n10 n5 VDD VDD sg13_lv_pmos w=7.5e-07 l=1.3e-07 ng=1
MN9 n11 n8 VSS VSS sg13_lv_nmos w=3e-07 l=1.3e-07 ng=1
MP9 n11 n8 VDD VDD sg13_lv_pmos w=4.5e-07 l=1.3e-07 ng=1
MN10 n8 n0 n12 VSS sg13_lv_nmos w=1.5e-07 l=1.3e-07 ng=1
MN11 n12 n11 VSS VSS sg13_lv_nmos w=1.5e-07 l=1.3e-07 ng=1
MP10 n8 n1 n13 VDD sg13_lv_pmos w=1.5e-07 l=1.3e-07 ng=1
MP11 n13 n11 VDD VDD sg13_lv_pmos w=1.5e-07 l=1.3e-07 ng=1
MN12 Q n8 VSS VSS sg13_lv_nmos w=6.4e-07 l=1.3e-07 ng=1
MP12 Q n8 VDD VDD sg13_lv_pmos w=9.8e-07 l=1.3e-07 ng=1
MN13 QN n11 VSS VSS sg13_lv_nmos w=6.4e-07 l=1.3e-07 ng=1
MP13 QN n11 VDD VDD sg13_lv_pmos w=9.8e-07 l=1.3e-07 ng=1
.ENDS

****************************************
* Cell : DFQQN_D2
* Description : D flip-flop with outputs Q and QN.
* ┌───────┬─────┬─────┬──────┬───────────────┐
* │ CLK   │   D │   Q │   QN │ Description   │
* ├───────┼─────┼─────┼──────┼───────────────┤
* │ R     │   0 │   0 │    1 │ Write 0       │
* ├───────┼─────┼─────┼──────┼───────────────┤
* │ R     │   1 │   1 │    0 │ Write 1       │
* └───────┴─────┴─────┴──────┴───────────────┘
****************************************
.SUBCKT DFQQN_D2 D CLK Q QN VDD VSS
*.PININFO CLK:I D:I Q:O QN:O VDD:B VSS:B
MN0 n0 CLK VSS VSS sg13_lv_nmos w=4e-07 l=1.3e-07 ng=1
MP0 n0 CLK VDD VDD sg13_lv_pmos w=6e-07 l=1.3e-07 ng=1
MN1 n1 n0 VSS VSS sg13_lv_nmos w=3e-07 l=1.3e-07 ng=1
MP1 n1 n0 VDD VDD sg13_lv_pmos w=4.5e-07 l=1.3e-07 ng=1
MN2 n2 n0 n3 VSS sg13_lv_nmos w=2.5e-07 l=1.3e-07 ng=1
MN3 n3 D VSS VSS sg13_lv_nmos w=2.5e-07 l=1.3e-07 ng=1
MP2 n2 n1 n4 VDD sg13_lv_pmos w=3.8e-07 l=1.3e-07 ng=1
MP3 n4 D VDD VDD sg13_lv_pmos w=3.8e-07 l=1.3e-07 ng=1
MN4 n5 n2 VSS VSS sg13_lv_nmos w=3e-07 l=1.3e-07 ng=1
MP4 n5 n2 VDD VDD sg13_lv_pmos w=4.5e-07 l=1.3e-07 ng=1
MN5 n2 n1 n6 VSS sg13_lv_nmos w=1.5e-07 l=1.3e-07 ng=1
MN6 n6 n5 VSS VSS sg13_lv_nmos w=1.5e-07 l=1.3e-07 ng=1
MP5 n2 n0 n7 VDD sg13_lv_pmos w=2.3e-07 l=1.3e-07 ng=1
MP6 n7 n5 VDD VDD sg13_lv_pmos w=2.3e-07 l=1.3e-07 ng=1
MN7 n8 n1 n9 VSS sg13_lv_nmos w=9.2e-07 l=1.3e-07 ng=1
MN8 n9 n5 VSS VSS sg13_lv_nmos w=9.2e-07 l=1.3e-07 ng=1
MP7 n8 n0 n10 VDD sg13_lv_pmos w=1.38e-06 l=1.3e-07 ng=1
MP8 n10 n5 VDD VDD sg13_lv_pmos w=1.38e-06 l=1.3e-07 ng=1
MN9 n11 n8 VSS VSS sg13_lv_nmos w=5e-07 l=1.3e-07 ng=1
MP9 n11 n8 VDD VDD sg13_lv_pmos w=7.5e-07 l=1.3e-07 ng=1
MN10 n8 n0 n12 VSS sg13_lv_nmos w=1.5e-07 l=1.3e-07 ng=1
MN11 n12 n11 VSS VSS sg13_lv_nmos w=1.5e-07 l=1.3e-07 ng=1
MP10 n8 n1 n13 VDD sg13_lv_pmos w=1.5e-07 l=1.3e-07 ng=1
MP11 n13 n11 VDD VDD sg13_lv_pmos w=1.5e-07 l=1.3e-07 ng=1
MN12 Q n8 VSS VSS sg13_lv_nmos w=1.07e-06 l=1.3e-07 ng=1
MP12 Q n8 VDD VDD sg13_lv_pmos w=1.6e-06 l=1.3e-07 ng=1
MN13 QN n11 VSS VSS sg13_lv_nmos w=1.07e-06 l=1.3e-07 ng=1
MP13 QN n11 VDD VDD sg13_lv_pmos w=1.6e-06 l=1.3e-07 ng=1
.ENDS

****************************************
* Cell : DFQQN_D4
* Description : D flip-flop with outputs Q and QN.
* ┌───────┬─────┬─────┬──────┬───────────────┐
* │ CLK   │   D │   Q │   QN │ Description   │
* ├───────┼─────┼─────┼──────┼───────────────┤
* │ R     │   0 │   0 │    1 │ Write 0       │
* ├───────┼─────┼─────┼──────┼───────────────┤
* │ R     │   1 │   1 │    0 │ Write 1       │
* └───────┴─────┴─────┴──────┴───────────────┘
****************************************
.SUBCKT DFQQN_D4 D CLK Q QN VDD VSS
*.PININFO CLK:I D:I Q:O QN:O VDD:B VSS:B
MN0 n0 CLK VSS VSS sg13_lv_nmos w=7.5e-07 l=1.3e-07 ng=1
MP0 n0 CLK VDD VDD sg13_lv_pmos w=1.12e-06 l=1.3e-07 ng=1
MN1 n1 n0 VSS VSS sg13_lv_nmos w=5.5e-07 l=1.3e-07 ng=1
MP1 n1 n0 VDD VDD sg13_lv_pmos w=8.3e-07 l=1.3e-07 ng=1
MN2 n2 n0 n3 VSS sg13_lv_nmos w=4e-07 l=1.3e-07 ng=1
MN3 n3 D VSS VSS sg13_lv_nmos w=4e-07 l=1.3e-07 ng=1
MP2 n2 n1 n4 VDD sg13_lv_pmos w=6e-07 l=1.3e-07 ng=1
MP3 n4 D VDD VDD sg13_lv_pmos w=6e-07 l=1.3e-07 ng=1
MN4 n5 n2 VSS VSS sg13_lv_nmos w=6.5e-07 l=1.3e-07 ng=1
MP4 n5 n2 VDD VDD sg13_lv_pmos w=9.8e-07 l=1.3e-07 ng=1
MN5 n2 n1 n6 VSS sg13_lv_nmos w=1.5e-07 l=1.3e-07 ng=1
MN6 n6 n5 VSS VSS sg13_lv_nmos w=1.5e-07 l=1.3e-07 ng=1
MP5 n2 n0 n7 VDD sg13_lv_pmos w=2.3e-07 l=1.3e-07 ng=1
MP6 n7 n5 VDD VDD sg13_lv_pmos w=2.3e-07 l=1.3e-07 ng=1
MN7 n8 n1 n9 VSS sg13_lv_nmos w=2e-06 l=1.3e-07 ng=2
MN8 n9 n5 VSS VSS sg13_lv_nmos w=2e-06 l=1.3e-07 ng=2
MP7 n8 n0 n10 VDD sg13_lv_pmos w=3e-06 l=1.3e-07 ng=2
MP8 n10 n5 VDD VDD sg13_lv_pmos w=3e-06 l=1.3e-07 ng=2
MN9 n11 n8 VSS VSS sg13_lv_nmos w=8.5e-07 l=1.3e-07 ng=1
MP9 n11 n8 VDD VDD sg13_lv_pmos w=1.28e-06 l=1.3e-07 ng=1
MN10 n8 n0 n12 VSS sg13_lv_nmos w=1.5e-07 l=1.3e-07 ng=1
MN11 n12 n11 VSS VSS sg13_lv_nmos w=1.5e-07 l=1.3e-07 ng=1
MP10 n8 n1 n13 VDD sg13_lv_pmos w=1.5e-07 l=1.3e-07 ng=1
MP11 n13 n11 VDD VDD sg13_lv_pmos w=1.5e-07 l=1.3e-07 ng=1
MN12 Q n8 VSS VSS sg13_lv_nmos w=2.14e-06 l=1.3e-07 ng=3
MP12 Q n8 VDD VDD sg13_lv_pmos w=3.2e-06 l=1.3e-07 ng=3
MN13 QN n11 VSS VSS sg13_lv_nmos w=2.14e-06 l=1.3e-07 ng=3
MP13 QN n11 VDD VDD sg13_lv_pmos w=3.2e-06 l=1.3e-07 ng=3
.ENDS

****************************************
* Cell : DFQQN_DL
* Description : D flip-flop with outputs Q and QN.
* ┌───────┬─────┬─────┬──────┬───────────────┐
* │ CLK   │   D │   Q │   QN │ Description   │
* ├───────┼─────┼─────┼──────┼───────────────┤
* │ R     │   0 │   0 │    1 │ Write 0       │
* ├───────┼─────┼─────┼──────┼───────────────┤
* │ R     │   1 │   1 │    0 │ Write 1       │
* └───────┴─────┴─────┴──────┴───────────────┘
****************************************
.SUBCKT DFQQN_DL D CLK Q QN VDD VSS
*.PININFO CLK:I D:I Q:O QN:O VDD:B VSS:B
MN0 n0 CLK VSS VSS sg13_lv_nmos w=2e-07 l=1.3e-07 ng=1
MP0 n0 CLK VDD VDD sg13_lv_pmos w=3e-07 l=1.3e-07 ng=1
MN1 n1 n0 VSS VSS sg13_lv_nmos w=2e-07 l=1.3e-07 ng=1
MP1 n1 n0 VDD VDD sg13_lv_pmos w=3e-07 l=1.3e-07 ng=1
MN2 n2 D n3 VSS sg13_lv_nmos w=1.5e-07 l=1.3e-07 ng=1
MN3 n3 n0 VSS VSS sg13_lv_nmos w=1.5e-07 l=1.3e-07 ng=1
MP2 n2 D n4 VDD sg13_lv_pmos w=2.3e-07 l=1.3e-07 ng=1
MP3 n4 n1 VDD VDD sg13_lv_pmos w=2.3e-07 l=1.3e-07 ng=1
MN4 n5 n2 VSS VSS sg13_lv_nmos w=1.5e-07 l=1.3e-07 ng=1
MP4 n5 n2 VDD VDD sg13_lv_pmos w=2.3e-07 l=1.3e-07 ng=1
MN5 n2 n1 n6 VSS sg13_lv_nmos w=1.5e-07 l=1.3e-07 ng=1
MN6 n6 n5 VSS VSS sg13_lv_nmos w=1.5e-07 l=1.3e-07 ng=1
MP5 n2 n0 n7 VDD sg13_lv_pmos w=2.3e-07 l=1.3e-07 ng=1
MP6 n7 n5 VDD VDD sg13_lv_pmos w=2.3e-07 l=1.3e-07 ng=1
MN7 n8 n1 n9 VSS sg13_lv_nmos w=2e-07 l=1.3e-07 ng=1
MN8 n9 n5 VSS VSS sg13_lv_nmos w=2e-07 l=1.3e-07 ng=1
MP7 n8 n0 n10 VDD sg13_lv_pmos w=3e-07 l=1.3e-07 ng=1
MP8 n10 n5 VDD VDD sg13_lv_pmos w=3e-07 l=1.3e-07 ng=1
MN9 n11 n8 VSS VSS sg13_lv_nmos w=1.5e-07 l=1.3e-07 ng=1
MP9 n11 n8 VDD VDD sg13_lv_pmos w=2.3e-07 l=1.3e-07 ng=1
MN10 n8 n0 n12 VSS sg13_lv_nmos w=1.5e-07 l=1.3e-07 ng=1
MN11 n12 n11 VSS VSS sg13_lv_nmos w=1.5e-07 l=1.3e-07 ng=1
MP10 n8 n1 n13 VDD sg13_lv_pmos w=1.5e-07 l=1.3e-07 ng=1
MP11 n13 n11 VDD VDD sg13_lv_pmos w=1.5e-07 l=1.3e-07 ng=1
MN12 Q n8 VSS VSS sg13_lv_nmos w=3.2e-07 l=1.3e-07 ng=1
MP12 Q n8 VDD VDD sg13_lv_pmos w=4.9e-07 l=1.3e-07 ng=1
MN13 QN n11 VSS VSS sg13_lv_nmos w=3.2e-07 l=1.3e-07 ng=1
MP13 QN n11 VDD VDD sg13_lv_pmos w=4.9e-07 l=1.3e-07 ng=1
.ENDS

****************************************
* Cell : DFQ_D1
* Description : D flip-flop with output Q.
* ┌───────┬─────┬─────┬───────────────┐
* │ CLK   │   D │   Q │ Description   │
* ├───────┼─────┼─────┼───────────────┤
* │ R     │   0 │   0 │ Write 0       │
* ├───────┼─────┼─────┼───────────────┤
* │ R     │   1 │   1 │ Write 1       │
* └───────┴─────┴─────┴───────────────┘
****************************************
.SUBCKT DFQ_D1 D CLK Q VDD VSS
*.PININFO CLK:I D:I Q:O VDD:B VSS:B
MN0 n0 CLK VSS VSS sg13_lv_nmos w=3e-07 l=1.3e-07 ng=1
MP0 n0 CLK VDD VDD sg13_lv_pmos w=4.5e-07 l=1.3e-07 ng=1
MN1 n1 n0 VSS VSS sg13_lv_nmos w=2e-07 l=1.3e-07 ng=1
MP1 n1 n0 VDD VDD sg13_lv_pmos w=3e-07 l=1.3e-07 ng=1
MN2 n2 D n3 VSS sg13_lv_nmos w=1.5e-07 l=1.3e-07 ng=1
MN3 n3 n0 VSS VSS sg13_lv_nmos w=1.5e-07 l=1.3e-07 ng=1
MP2 n2 D n4 VDD sg13_lv_pmos w=2.3e-07 l=1.3e-07 ng=1
MP3 n4 n1 VDD VDD sg13_lv_pmos w=2.3e-07 l=1.3e-07 ng=1
MN4 n5 n2 VSS VSS sg13_lv_nmos w=2e-07 l=1.3e-07 ng=1
MP4 n5 n2 VDD VDD sg13_lv_pmos w=3e-07 l=1.3e-07 ng=1
MN5 n2 n1 n6 VSS sg13_lv_nmos w=1.5e-07 l=1.3e-07 ng=1
MN6 n6 n5 VSS VSS sg13_lv_nmos w=1.5e-07 l=1.3e-07 ng=1
MP5 n2 n0 n7 VDD sg13_lv_pmos w=2.3e-07 l=1.3e-07 ng=1
MP6 n7 n5 VDD VDD sg13_lv_pmos w=2.3e-07 l=1.3e-07 ng=1
MN7 n8 n1 n9 VSS sg13_lv_nmos w=5e-07 l=1.3e-07 ng=1
MN8 n9 n5 VSS VSS sg13_lv_nmos w=5e-07 l=1.3e-07 ng=1
MP7 n8 n0 n10 VDD sg13_lv_pmos w=7.5e-07 l=1.3e-07 ng=1
MP8 n10 n5 VDD VDD sg13_lv_pmos w=7.5e-07 l=1.3e-07 ng=1
MN9 n11 n8 VSS VSS sg13_lv_nmos w=2e-07 l=1.3e-07 ng=1
MP9 n11 n8 VDD VDD sg13_lv_pmos w=3e-07 l=1.3e-07 ng=1
MN10 n8 n0 n12 VSS sg13_lv_nmos w=1.5e-07 l=1.3e-07 ng=1
MN11 n12 n11 VSS VSS sg13_lv_nmos w=1.5e-07 l=1.3e-07 ng=1
MP10 n8 n1 n13 VDD sg13_lv_pmos w=1.5e-07 l=1.3e-07 ng=1
MP11 n13 n11 VDD VDD sg13_lv_pmos w=1.5e-07 l=1.3e-07 ng=1
MN12 Q n8 VSS VSS sg13_lv_nmos w=6.4e-07 l=1.3e-07 ng=1
MP12 Q n8 VDD VDD sg13_lv_pmos w=9.8e-07 l=1.3e-07 ng=1
.ENDS

****************************************
* Cell : DFQ_D2
* Description : D flip-flop with output Q.
* ┌───────┬─────┬─────┬───────────────┐
* │ CLK   │   D │   Q │ Description   │
* ├───────┼─────┼─────┼───────────────┤
* │ R     │   0 │   0 │ Write 0       │
* ├───────┼─────┼─────┼───────────────┤
* │ R     │   1 │   1 │ Write 1       │
* └───────┴─────┴─────┴───────────────┘
****************************************
.SUBCKT DFQ_D2 D CLK Q VDD VSS
*.PININFO CLK:I D:I Q:O VDD:B VSS:B
MN0 n0 CLK VSS VSS sg13_lv_nmos w=4.2e-07 l=1.3e-07 ng=1
MP0 n0 CLK VDD VDD sg13_lv_pmos w=6.3e-07 l=1.3e-07 ng=1
MN1 n1 n0 VSS VSS sg13_lv_nmos w=3.2e-07 l=1.3e-07 ng=1
MP1 n1 n0 VDD VDD sg13_lv_pmos w=4.8e-07 l=1.3e-07 ng=1
MN2 n2 n0 n3 VSS sg13_lv_nmos w=2e-07 l=1.3e-07 ng=1
MN3 n3 D VSS VSS sg13_lv_nmos w=2e-07 l=1.3e-07 ng=1
MP2 n2 n1 n4 VDD sg13_lv_pmos w=3e-07 l=1.3e-07 ng=1
MP3 n4 D VDD VDD sg13_lv_pmos w=3e-07 l=1.3e-07 ng=1
MN4 n5 n2 VSS VSS sg13_lv_nmos w=3e-07 l=1.3e-07 ng=1
MP4 n5 n2 VDD VDD sg13_lv_pmos w=4.5e-07 l=1.3e-07 ng=1
MN5 n2 n1 n6 VSS sg13_lv_nmos w=1.5e-07 l=1.3e-07 ng=1
MN6 n6 n5 VSS VSS sg13_lv_nmos w=1.5e-07 l=1.3e-07 ng=1
MP5 n2 n0 n7 VDD sg13_lv_pmos w=2.3e-07 l=1.3e-07 ng=1
MP6 n7 n5 VDD VDD sg13_lv_pmos w=2.3e-07 l=1.3e-07 ng=1
MN7 n8 n1 n9 VSS sg13_lv_nmos w=9e-07 l=1.3e-07 ng=1
MN8 n9 n5 VSS VSS sg13_lv_nmos w=9e-07 l=1.3e-07 ng=1
MP7 n8 n0 n10 VDD sg13_lv_pmos w=1.35e-06 l=1.3e-07 ng=1
MP8 n10 n5 VDD VDD sg13_lv_pmos w=1.35e-06 l=1.3e-07 ng=1
MN9 n11 n8 VSS VSS sg13_lv_nmos w=2e-07 l=1.3e-07 ng=1
MP9 n11 n8 VDD VDD sg13_lv_pmos w=2e-07 l=1.3e-07 ng=1
MN10 n8 n0 n12 VSS sg13_lv_nmos w=1.5e-07 l=1.3e-07 ng=1
MN11 n12 n11 VSS VSS sg13_lv_nmos w=1.5e-07 l=1.3e-07 ng=1
MP10 n8 n1 n13 VDD sg13_lv_pmos w=1.5e-07 l=1.3e-07 ng=1
MP11 n13 n11 VDD VDD sg13_lv_pmos w=1.5e-07 l=1.3e-07 ng=1
MN12 Q n8 VSS VSS sg13_lv_nmos w=1.07e-06 l=1.3e-07 ng=1
MP12 Q n8 VDD VDD sg13_lv_pmos w=1.6e-06 l=1.3e-07 ng=1
.ENDS

****************************************
* Cell : DFQ_D4
* Description : D flip-flop with output Q.
* ┌───────┬─────┬─────┬───────────────┐
* │ CLK   │   D │   Q │ Description   │
* ├───────┼─────┼─────┼───────────────┤
* │ R     │   0 │   0 │ Write 0       │
* ├───────┼─────┼─────┼───────────────┤
* │ R     │   1 │   1 │ Write 1       │
* └───────┴─────┴─────┴───────────────┘
****************************************
.SUBCKT DFQ_D4 D CLK Q VDD VSS
*.PININFO CLK:I D:I Q:O VDD:B VSS:B
MN0 n0 CLK VSS VSS sg13_lv_nmos w=7.5e-07 l=1.3e-07 ng=1
MP0 n0 CLK VDD VDD sg13_lv_pmos w=1.12e-06 l=1.3e-07 ng=1
MN1 n1 n0 VSS VSS sg13_lv_nmos w=5.5e-07 l=1.3e-07 ng=1
MP1 n1 n0 VDD VDD sg13_lv_pmos w=8.3e-07 l=1.3e-07 ng=1
MN2 n2 n0 n3 VSS sg13_lv_nmos w=4e-07 l=1.3e-07 ng=1
MN3 n3 D VSS VSS sg13_lv_nmos w=4e-07 l=1.3e-07 ng=1
MP2 n2 n1 n4 VDD sg13_lv_pmos w=6e-07 l=1.3e-07 ng=1
MP3 n4 D VDD VDD sg13_lv_pmos w=6e-07 l=1.3e-07 ng=1
MN4 n5 n2 VSS VSS sg13_lv_nmos w=6.5e-07 l=1.3e-07 ng=1
MP4 n5 n2 VDD VDD sg13_lv_pmos w=9.8e-07 l=1.3e-07 ng=1
MN5 n2 n1 n6 VSS sg13_lv_nmos w=1.5e-07 l=1.3e-07 ng=1
MN6 n6 n5 VSS VSS sg13_lv_nmos w=1.5e-07 l=1.3e-07 ng=1
MP5 n2 n0 n7 VDD sg13_lv_pmos w=2.3e-07 l=1.3e-07 ng=1
MP6 n7 n5 VDD VDD sg13_lv_pmos w=2.3e-07 l=1.3e-07 ng=1
MN7 n8 n1 n9 VSS sg13_lv_nmos w=2e-06 l=1.3e-07 ng=2
MN8 n9 n5 VSS VSS sg13_lv_nmos w=2e-06 l=1.3e-07 ng=2
MP7 n8 n0 n10 VDD sg13_lv_pmos w=3e-06 l=1.3e-07 ng=2
MP8 n10 n5 VDD VDD sg13_lv_pmos w=3e-06 l=1.3e-07 ng=2
MN9 n11 n8 VSS VSS sg13_lv_nmos w=3e-07 l=1.3e-07 ng=1
MP9 n11 n8 VDD VDD sg13_lv_pmos w=3e-07 l=1.3e-07 ng=1
MN10 n8 n0 n12 VSS sg13_lv_nmos w=1.5e-07 l=1.3e-07 ng=1
MN11 n12 n11 VSS VSS sg13_lv_nmos w=1.5e-07 l=1.3e-07 ng=1
MP10 n8 n1 n13 VDD sg13_lv_pmos w=1.5e-07 l=1.3e-07 ng=1
MP11 n13 n11 VDD VDD sg13_lv_pmos w=1.5e-07 l=1.3e-07 ng=1
MN12 Q n8 VSS VSS sg13_lv_nmos w=2.14e-06 l=1.3e-07 ng=3
MP12 Q n8 VDD VDD sg13_lv_pmos w=3.2e-06 l=1.3e-07 ng=3
.ENDS

****************************************
* Cell : DFQ_DL
* Description : D flip-flop with output Q.
* ┌───────┬─────┬─────┬───────────────┐
* │ CLK   │   D │   Q │ Description   │
* ├───────┼─────┼─────┼───────────────┤
* │ R     │   0 │   0 │ Write 0       │
* ├───────┼─────┼─────┼───────────────┤
* │ R     │   1 │   1 │ Write 1       │
* └───────┴─────┴─────┴───────────────┘
****************************************
.SUBCKT DFQ_DL D CLK Q VDD VSS
*.PININFO CLK:I D:I Q:O VDD:B VSS:B
MN0 n0 CLK VSS VSS sg13_lv_nmos w=2e-07 l=1.3e-07 ng=1
MP0 n0 CLK VDD VDD sg13_lv_pmos w=3e-07 l=1.3e-07 ng=1
MN1 n1 n0 VSS VSS sg13_lv_nmos w=2e-07 l=1.3e-07 ng=1
MP1 n1 n0 VDD VDD sg13_lv_pmos w=3e-07 l=1.3e-07 ng=1
MN2 n2 D n3 VSS sg13_lv_nmos w=1.5e-07 l=1.3e-07 ng=1
MN3 n3 n0 VSS VSS sg13_lv_nmos w=1.5e-07 l=1.3e-07 ng=1
MP2 n2 D n4 VDD sg13_lv_pmos w=2.3e-07 l=1.3e-07 ng=1
MP3 n4 n1 VDD VDD sg13_lv_pmos w=2.3e-07 l=1.3e-07 ng=1
MN4 n5 n2 VSS VSS sg13_lv_nmos w=2e-07 l=1.3e-07 ng=1
MP4 n5 n2 VDD VDD sg13_lv_pmos w=3e-07 l=1.3e-07 ng=1
MN5 n2 n1 n6 VSS sg13_lv_nmos w=1.5e-07 l=1.3e-07 ng=1
MN6 n6 n5 VSS VSS sg13_lv_nmos w=1.5e-07 l=1.3e-07 ng=1
MP5 n2 n0 n7 VDD sg13_lv_pmos w=2.3e-07 l=1.3e-07 ng=1
MP6 n7 n5 VDD VDD sg13_lv_pmos w=2.3e-07 l=1.3e-07 ng=1
MN7 n8 n1 n9 VSS sg13_lv_nmos w=4e-07 l=1.3e-07 ng=1
MN8 n9 n5 VSS VSS sg13_lv_nmos w=4e-07 l=1.3e-07 ng=1
MP7 n8 n0 n10 VDD sg13_lv_pmos w=6e-07 l=1.3e-07 ng=1
MP8 n10 n5 VDD VDD sg13_lv_pmos w=6e-07 l=1.3e-07 ng=1
MN9 n11 n8 VSS VSS sg13_lv_nmos w=2e-07 l=1.3e-07 ng=1
MP9 n11 n8 VDD VDD sg13_lv_pmos w=3e-07 l=1.3e-07 ng=1
MN10 n8 n0 n12 VSS sg13_lv_nmos w=1.5e-07 l=1.3e-07 ng=1
MN11 n12 n11 VSS VSS sg13_lv_nmos w=1.5e-07 l=1.3e-07 ng=1
MP10 n8 n1 n13 VDD sg13_lv_pmos w=1.5e-07 l=1.3e-07 ng=1
MP11 n13 n11 VDD VDD sg13_lv_pmos w=1.5e-07 l=1.3e-07 ng=1
MN12 Q n8 VSS VSS sg13_lv_nmos w=3.2e-07 l=1.3e-07 ng=1
MP12 Q n8 VDD VDD sg13_lv_pmos w=4.9e-07 l=1.3e-07 ng=1
.ENDS

****************************************
* Cell : DFRQN_D1
* Description : D flip-flop with synchronous reset and output QN.
* ┌───────┬─────┬──────┬──────┬───────────────┐
* │ CLK   │ D   │   RN │   QN │ Description   │
* ├───────┼─────┼──────┼──────┼───────────────┤
* │ R     │ 0   │    1 │    1 │ Write 0       │
* ├───────┼─────┼──────┼──────┼───────────────┤
* │ R     │ 1   │    1 │    0 │ Write 1       │
* ├───────┼─────┼──────┼──────┼───────────────┤
* │ R     │ -   │    0 │    1 │ Clear         │
* └───────┴─────┴──────┴──────┴───────────────┘
****************************************
.SUBCKT DFRQN_D1 D CLK RN QN VDD VSS
*.PININFO CLK:I D:I RN:I QN:O VDD:B VSS:B
MN0 n0 CLK VSS VSS sg13_lv_nmos w=3e-07 l=1.3e-07 ng=1
MP0 n0 CLK VDD VDD sg13_lv_pmos w=4.5e-07 l=1.3e-07 ng=1
MN1 n1 n0 VSS VSS sg13_lv_nmos w=2e-07 l=1.3e-07 ng=1
MP1 n1 n0 VDD VDD sg13_lv_pmos w=3e-07 l=1.3e-07 ng=1
MN2 n2 RN VSS VSS sg13_lv_nmos w=2e-07 l=1.3e-07 ng=1
MN3 n3 D n2 VSS sg13_lv_nmos w=2e-07 l=1.3e-07 ng=1
MP2 n3 RN VDD VDD sg13_lv_pmos w=2.3e-07 l=1.3e-07 ng=1
MP3 n3 D VDD VDD sg13_lv_pmos w=2.3e-07 l=1.3e-07 ng=1
MN4 n4 n3 n5 VSS sg13_lv_nmos w=1.5e-07 l=1.3e-07 ng=1
MN5 n5 n0 VSS VSS sg13_lv_nmos w=1.5e-07 l=1.3e-07 ng=1
MP4 n4 n3 n6 VDD sg13_lv_pmos w=2.3e-07 l=1.3e-07 ng=1
MP5 n6 n1 VDD VDD sg13_lv_pmos w=2.3e-07 l=1.3e-07 ng=1
MN6 n7 n4 VSS VSS sg13_lv_nmos w=2e-07 l=1.3e-07 ng=1
MP6 n7 n4 VDD VDD sg13_lv_pmos w=3e-07 l=1.3e-07 ng=1
MN7 n4 n1 n8 VSS sg13_lv_nmos w=1.5e-07 l=1.3e-07 ng=1
MN8 n8 n7 VSS VSS sg13_lv_nmos w=1.5e-07 l=1.3e-07 ng=1
MP7 n4 n0 n9 VDD sg13_lv_pmos w=2.3e-07 l=1.3e-07 ng=1
MP8 n9 n7 VDD VDD sg13_lv_pmos w=2.3e-07 l=1.3e-07 ng=1
MN9 n10 n1 n11 VSS sg13_lv_nmos w=5e-07 l=1.3e-07 ng=1
MN10 n11 n7 VSS VSS sg13_lv_nmos w=5e-07 l=1.3e-07 ng=1
MP9 n10 n0 n12 VDD sg13_lv_pmos w=7.5e-07 l=1.3e-07 ng=1
MP10 n12 n7 VDD VDD sg13_lv_pmos w=7.5e-07 l=1.3e-07 ng=1
MN11 n13 n10 VSS VSS sg13_lv_nmos w=3e-07 l=1.3e-07 ng=1
MP11 n13 n10 VDD VDD sg13_lv_pmos w=4.5e-07 l=1.3e-07 ng=1
MN12 n10 n0 n14 VSS sg13_lv_nmos w=1.5e-07 l=1.3e-07 ng=1
MN13 n14 n13 VSS VSS sg13_lv_nmos w=1.5e-07 l=1.3e-07 ng=1
MP12 n10 n1 n15 VDD sg13_lv_pmos w=1.5e-07 l=1.3e-07 ng=1
MP13 n15 n13 VDD VDD sg13_lv_pmos w=1.5e-07 l=1.3e-07 ng=1
MN14 QN n10 VSS VSS sg13_lv_nmos w=6.4e-07 l=1.3e-07 ng=1
MP14 QN n10 VDD VDD sg13_lv_pmos w=9.8e-07 l=1.3e-07 ng=1
.ENDS

****************************************
* Cell : DFRQN_D2
* Description : D flip-flop with synchronous reset and output QN.
* ┌───────┬─────┬──────┬──────┬───────────────┐
* │ CLK   │ D   │   RN │   QN │ Description   │
* ├───────┼─────┼──────┼──────┼───────────────┤
* │ R     │ 0   │    1 │    1 │ Write 0       │
* ├───────┼─────┼──────┼──────┼───────────────┤
* │ R     │ 1   │    1 │    0 │ Write 1       │
* ├───────┼─────┼──────┼──────┼───────────────┤
* │ R     │ -   │    0 │    1 │ Clear         │
* └───────┴─────┴──────┴──────┴───────────────┘
****************************************
.SUBCKT DFRQN_D2 D CLK RN QN VDD VSS
*.PININFO CLK:I D:I RN:I QN:O VDD:B VSS:B
MN0 n0 CLK VSS VSS sg13_lv_nmos w=4e-07 l=1.3e-07 ng=1
MP0 n0 CLK VDD VDD sg13_lv_pmos w=6e-07 l=1.3e-07 ng=1
MN1 n1 n0 VSS VSS sg13_lv_nmos w=3e-07 l=1.3e-07 ng=1
MP1 n1 n0 VDD VDD sg13_lv_pmos w=4.5e-07 l=1.3e-07 ng=1
MN2 n2 RN VSS VSS sg13_lv_nmos w=3e-07 l=1.3e-07 ng=1
MN3 n3 D n2 VSS sg13_lv_nmos w=3e-07 l=1.3e-07 ng=1
MP2 n3 RN VDD VDD sg13_lv_pmos w=3.3e-07 l=1.3e-07 ng=1
MP3 n3 D VDD VDD sg13_lv_pmos w=3.3e-07 l=1.3e-07 ng=1
MN4 n4 n0 n5 VSS sg13_lv_nmos w=2.5e-07 l=1.3e-07 ng=1
MN5 n5 n3 VSS VSS sg13_lv_nmos w=2.5e-07 l=1.3e-07 ng=1
MP4 n4 n1 n6 VDD sg13_lv_pmos w=3.8e-07 l=1.3e-07 ng=1
MP5 n6 n3 VDD VDD sg13_lv_pmos w=3.8e-07 l=1.3e-07 ng=1
MN6 n7 n4 VSS VSS sg13_lv_nmos w=3e-07 l=1.3e-07 ng=1
MP6 n7 n4 VDD VDD sg13_lv_pmos w=4.5e-07 l=1.3e-07 ng=1
MN7 n4 n1 n8 VSS sg13_lv_nmos w=1.5e-07 l=1.3e-07 ng=1
MN8 n8 n7 VSS VSS sg13_lv_nmos w=1.5e-07 l=1.3e-07 ng=1
MP7 n4 n0 n9 VDD sg13_lv_pmos w=2.3e-07 l=1.3e-07 ng=1
MP8 n9 n7 VDD VDD sg13_lv_pmos w=2.3e-07 l=1.3e-07 ng=1
MN9 n10 n1 n11 VSS sg13_lv_nmos w=9.2e-07 l=1.3e-07 ng=1
MN10 n11 n7 VSS VSS sg13_lv_nmos w=9.2e-07 l=1.3e-07 ng=1
MP9 n10 n0 n12 VDD sg13_lv_pmos w=1.38e-06 l=1.3e-07 ng=1
MP10 n12 n7 VDD VDD sg13_lv_pmos w=1.38e-06 l=1.3e-07 ng=1
MN11 n13 n10 VSS VSS sg13_lv_nmos w=5e-07 l=1.3e-07 ng=1
MP11 n13 n10 VDD VDD sg13_lv_pmos w=7.5e-07 l=1.3e-07 ng=1
MN12 n10 n0 n14 VSS sg13_lv_nmos w=1.5e-07 l=1.3e-07 ng=1
MN13 n14 n13 VSS VSS sg13_lv_nmos w=1.5e-07 l=1.3e-07 ng=1
MP12 n10 n1 n15 VDD sg13_lv_pmos w=1.5e-07 l=1.3e-07 ng=1
MP13 n15 n13 VDD VDD sg13_lv_pmos w=1.5e-07 l=1.3e-07 ng=1
MN14 QN n10 VSS VSS sg13_lv_nmos w=1.07e-06 l=1.3e-07 ng=1
MP14 QN n10 VDD VDD sg13_lv_pmos w=1.6e-06 l=1.3e-07 ng=1
.ENDS

****************************************
* Cell : DFRQN_DL
* Description : D flip-flop with synchronous reset and output QN.
* ┌───────┬─────┬──────┬──────┬───────────────┐
* │ CLK   │ D   │   RN │   QN │ Description   │
* ├───────┼─────┼──────┼──────┼───────────────┤
* │ R     │ 0   │    1 │    1 │ Write 0       │
* ├───────┼─────┼──────┼──────┼───────────────┤
* │ R     │ 1   │    1 │    0 │ Write 1       │
* ├───────┼─────┼──────┼──────┼───────────────┤
* │ R     │ -   │    0 │    1 │ Clear         │
* └───────┴─────┴──────┴──────┴───────────────┘
****************************************
.SUBCKT DFRQN_DL D CLK RN QN VDD VSS
*.PININFO CLK:I D:I RN:I QN:O VDD:B VSS:B
MN0 n0 CLK VSS VSS sg13_lv_nmos w=2e-07 l=1.3e-07 ng=1
MP0 n0 CLK VDD VDD sg13_lv_pmos w=3e-07 l=1.3e-07 ng=1
MN1 n1 n0 VSS VSS sg13_lv_nmos w=2e-07 l=1.3e-07 ng=1
MP1 n1 n0 VDD VDD sg13_lv_pmos w=3e-07 l=1.3e-07 ng=1
MN2 n2 RN VSS VSS sg13_lv_nmos w=2e-07 l=1.3e-07 ng=1
MN3 n3 D n2 VSS sg13_lv_nmos w=2e-07 l=1.3e-07 ng=1
MP2 n3 RN VDD VDD sg13_lv_pmos w=2.3e-07 l=1.3e-07 ng=1
MP3 n3 D VDD VDD sg13_lv_pmos w=2.3e-07 l=1.3e-07 ng=1
MN4 n4 n3 n5 VSS sg13_lv_nmos w=1.5e-07 l=1.3e-07 ng=1
MN5 n5 n0 VSS VSS sg13_lv_nmos w=1.5e-07 l=1.3e-07 ng=1
MP4 n4 n3 n6 VDD sg13_lv_pmos w=2.3e-07 l=1.3e-07 ng=1
MP5 n6 n1 VDD VDD sg13_lv_pmos w=2.3e-07 l=1.3e-07 ng=1
MN6 n7 n4 VSS VSS sg13_lv_nmos w=1.5e-07 l=1.3e-07 ng=1
MP6 n7 n4 VDD VDD sg13_lv_pmos w=2.3e-07 l=1.3e-07 ng=1
MN7 n4 n1 n8 VSS sg13_lv_nmos w=1.5e-07 l=1.3e-07 ng=1
MN8 n8 n7 VSS VSS sg13_lv_nmos w=1.5e-07 l=1.3e-07 ng=1
MP7 n4 n0 n9 VDD sg13_lv_pmos w=2.3e-07 l=1.3e-07 ng=1
MP8 n9 n7 VDD VDD sg13_lv_pmos w=2.3e-07 l=1.3e-07 ng=1
MN9 n10 n1 n11 VSS sg13_lv_nmos w=2e-07 l=1.3e-07 ng=1
MN10 n11 n7 VSS VSS sg13_lv_nmos w=2e-07 l=1.3e-07 ng=1
MP9 n10 n0 n12 VDD sg13_lv_pmos w=3e-07 l=1.3e-07 ng=1
MP10 n12 n7 VDD VDD sg13_lv_pmos w=3e-07 l=1.3e-07 ng=1
MN11 n13 n10 VSS VSS sg13_lv_nmos w=1.5e-07 l=1.3e-07 ng=1
MP11 n13 n10 VDD VDD sg13_lv_pmos w=2.3e-07 l=1.3e-07 ng=1
MN12 n10 n0 n14 VSS sg13_lv_nmos w=1.5e-07 l=1.3e-07 ng=1
MN13 n14 n13 VSS VSS sg13_lv_nmos w=1.5e-07 l=1.3e-07 ng=1
MP12 n10 n1 n15 VDD sg13_lv_pmos w=1.5e-07 l=1.3e-07 ng=1
MP13 n15 n13 VDD VDD sg13_lv_pmos w=1.5e-07 l=1.3e-07 ng=1
MN14 QN n10 VSS VSS sg13_lv_nmos w=3.2e-07 l=1.3e-07 ng=1
MP14 QN n10 VDD VDD sg13_lv_pmos w=4.9e-07 l=1.3e-07 ng=1
.ENDS

****************************************
* Cell : DFRQQN_D1
* Description : D flip-flop with synchronous reset and outputs Q and QN.
* ┌───────┬─────┬──────┬─────┬──────┬───────────────┐
* │ CLK   │ D   │   RN │   Q │   QN │ Description   │
* ├───────┼─────┼──────┼─────┼──────┼───────────────┤
* │ R     │ 0   │    1 │   0 │    1 │ Write 0       │
* ├───────┼─────┼──────┼─────┼──────┼───────────────┤
* │ R     │ 1   │    1 │   1 │    0 │ Write 1       │
* ├───────┼─────┼──────┼─────┼──────┼───────────────┤
* │ R     │ -   │    0 │   0 │    1 │ Clear         │
* └───────┴─────┴──────┴─────┴──────┴───────────────┘
****************************************
.SUBCKT DFRQQN_D1 D CLK RN Q QN VDD VSS
*.PININFO CLK:I D:I RN:I Q:O QN:O VDD:B VSS:B
MN0 n0 CLK VSS VSS sg13_lv_nmos w=3e-07 l=1.3e-07 ng=1
MP0 n0 CLK VDD VDD sg13_lv_pmos w=4.5e-07 l=1.3e-07 ng=1
MN1 n1 n0 VSS VSS sg13_lv_nmos w=2e-07 l=1.3e-07 ng=1
MP1 n1 n0 VDD VDD sg13_lv_pmos w=3e-07 l=1.3e-07 ng=1
MN2 n2 RN VSS VSS sg13_lv_nmos w=2e-07 l=1.3e-07 ng=1
MN3 n3 D n2 VSS sg13_lv_nmos w=2e-07 l=1.3e-07 ng=1
MP2 n3 RN VDD VDD sg13_lv_pmos w=2.3e-07 l=1.3e-07 ng=1
MP3 n3 D VDD VDD sg13_lv_pmos w=2.3e-07 l=1.3e-07 ng=1
MN4 n4 n3 n5 VSS sg13_lv_nmos w=1.5e-07 l=1.3e-07 ng=1
MN5 n5 n0 VSS VSS sg13_lv_nmos w=1.5e-07 l=1.3e-07 ng=1
MP4 n4 n3 n6 VDD sg13_lv_pmos w=2.3e-07 l=1.3e-07 ng=1
MP5 n6 n1 VDD VDD sg13_lv_pmos w=2.3e-07 l=1.3e-07 ng=1
MN6 n7 n4 VSS VSS sg13_lv_nmos w=2e-07 l=1.3e-07 ng=1
MP6 n7 n4 VDD VDD sg13_lv_pmos w=3e-07 l=1.3e-07 ng=1
MN7 n4 n1 n8 VSS sg13_lv_nmos w=1.5e-07 l=1.3e-07 ng=1
MN8 n8 n7 VSS VSS sg13_lv_nmos w=1.5e-07 l=1.3e-07 ng=1
MP7 n4 n0 n9 VDD sg13_lv_pmos w=2.3e-07 l=1.3e-07 ng=1
MP8 n9 n7 VDD VDD sg13_lv_pmos w=2.3e-07 l=1.3e-07 ng=1
MN9 n10 n1 n11 VSS sg13_lv_nmos w=5e-07 l=1.3e-07 ng=1
MN10 n11 n7 VSS VSS sg13_lv_nmos w=5e-07 l=1.3e-07 ng=1
MP9 n10 n0 n12 VDD sg13_lv_pmos w=7.5e-07 l=1.3e-07 ng=1
MP10 n12 n7 VDD VDD sg13_lv_pmos w=7.5e-07 l=1.3e-07 ng=1
MN11 n13 n10 VSS VSS sg13_lv_nmos w=3e-07 l=1.3e-07 ng=1
MP11 n13 n10 VDD VDD sg13_lv_pmos w=4.5e-07 l=1.3e-07 ng=1
MN12 n10 n0 n14 VSS sg13_lv_nmos w=1.5e-07 l=1.3e-07 ng=1
MN13 n14 n13 VSS VSS sg13_lv_nmos w=1.5e-07 l=1.3e-07 ng=1
MP12 n10 n1 n15 VDD sg13_lv_pmos w=1.5e-07 l=1.3e-07 ng=1
MP13 n15 n13 VDD VDD sg13_lv_pmos w=1.5e-07 l=1.3e-07 ng=1
MN14 Q n13 VSS VSS sg13_lv_nmos w=6.4e-07 l=1.3e-07 ng=1
MP14 Q n13 VDD VDD sg13_lv_pmos w=9.8e-07 l=1.3e-07 ng=1
MN15 QN n10 VSS VSS sg13_lv_nmos w=6.4e-07 l=1.3e-07 ng=1
MP15 QN n10 VDD VDD sg13_lv_pmos w=9.8e-07 l=1.3e-07 ng=1
.ENDS

****************************************
* Cell : DFRQQN_D2
* Description : D flip-flop with synchronous reset and outputs Q and QN.
* ┌───────┬─────┬──────┬─────┬──────┬───────────────┐
* │ CLK   │ D   │   RN │   Q │   QN │ Description   │
* ├───────┼─────┼──────┼─────┼──────┼───────────────┤
* │ R     │ 0   │    1 │   0 │    1 │ Write 0       │
* ├───────┼─────┼──────┼─────┼──────┼───────────────┤
* │ R     │ 1   │    1 │   1 │    0 │ Write 1       │
* ├───────┼─────┼──────┼─────┼──────┼───────────────┤
* │ R     │ -   │    0 │   0 │    1 │ Clear         │
* └───────┴─────┴──────┴─────┴──────┴───────────────┘
****************************************
.SUBCKT DFRQQN_D2 D CLK RN Q QN VDD VSS
*.PININFO CLK:I D:I RN:I Q:O QN:O VDD:B VSS:B
MN0 n0 CLK VSS VSS sg13_lv_nmos w=4e-07 l=1.3e-07 ng=1
MP0 n0 CLK VDD VDD sg13_lv_pmos w=6e-07 l=1.3e-07 ng=1
MN1 n1 n0 VSS VSS sg13_lv_nmos w=3e-07 l=1.3e-07 ng=1
MP1 n1 n0 VDD VDD sg13_lv_pmos w=4.5e-07 l=1.3e-07 ng=1
MN2 n2 RN VSS VSS sg13_lv_nmos w=3e-07 l=1.3e-07 ng=1
MN3 n3 D n2 VSS sg13_lv_nmos w=3e-07 l=1.3e-07 ng=1
MP2 n3 RN VDD VDD sg13_lv_pmos w=3.3e-07 l=1.3e-07 ng=1
MP3 n3 D VDD VDD sg13_lv_pmos w=3.3e-07 l=1.3e-07 ng=1
MN4 n4 n0 n5 VSS sg13_lv_nmos w=2.5e-07 l=1.3e-07 ng=1
MN5 n5 n3 VSS VSS sg13_lv_nmos w=2.5e-07 l=1.3e-07 ng=1
MP4 n4 n1 n6 VDD sg13_lv_pmos w=3.8e-07 l=1.3e-07 ng=1
MP5 n6 n3 VDD VDD sg13_lv_pmos w=3.8e-07 l=1.3e-07 ng=1
MN6 n7 n4 VSS VSS sg13_lv_nmos w=3e-07 l=1.3e-07 ng=1
MP6 n7 n4 VDD VDD sg13_lv_pmos w=4.5e-07 l=1.3e-07 ng=1
MN7 n4 n1 n8 VSS sg13_lv_nmos w=1.5e-07 l=1.3e-07 ng=1
MN8 n8 n7 VSS VSS sg13_lv_nmos w=1.5e-07 l=1.3e-07 ng=1
MP7 n4 n0 n9 VDD sg13_lv_pmos w=2.3e-07 l=1.3e-07 ng=1
MP8 n9 n7 VDD VDD sg13_lv_pmos w=2.3e-07 l=1.3e-07 ng=1
MN9 n10 n1 n11 VSS sg13_lv_nmos w=9.2e-07 l=1.3e-07 ng=1
MN10 n11 n7 VSS VSS sg13_lv_nmos w=9.2e-07 l=1.3e-07 ng=1
MP9 n10 n0 n12 VDD sg13_lv_pmos w=1.38e-06 l=1.3e-07 ng=1
MP10 n12 n7 VDD VDD sg13_lv_pmos w=1.38e-06 l=1.3e-07 ng=1
MN11 n13 n10 VSS VSS sg13_lv_nmos w=5e-07 l=1.3e-07 ng=1
MP11 n13 n10 VDD VDD sg13_lv_pmos w=7.5e-07 l=1.3e-07 ng=1
MN12 n10 n0 n14 VSS sg13_lv_nmos w=1.5e-07 l=1.3e-07 ng=1
MN13 n14 n13 VSS VSS sg13_lv_nmos w=1.5e-07 l=1.3e-07 ng=1
MP12 n10 n1 n15 VDD sg13_lv_pmos w=1.5e-07 l=1.3e-07 ng=1
MP13 n15 n13 VDD VDD sg13_lv_pmos w=1.5e-07 l=1.3e-07 ng=1
MN14 Q n13 VSS VSS sg13_lv_nmos w=1.07e-06 l=1.3e-07 ng=1
MP14 Q n13 VDD VDD sg13_lv_pmos w=1.6e-06 l=1.3e-07 ng=1
MN15 QN n10 VSS VSS sg13_lv_nmos w=1.07e-06 l=1.3e-07 ng=1
MP15 QN n10 VDD VDD sg13_lv_pmos w=1.6e-06 l=1.3e-07 ng=1
.ENDS

****************************************
* Cell : DFRQQN_DL
* Description : D flip-flop with synchronous reset and outputs Q and QN.
* ┌───────┬─────┬──────┬─────┬──────┬───────────────┐
* │ CLK   │ D   │   RN │   Q │   QN │ Description   │
* ├───────┼─────┼──────┼─────┼──────┼───────────────┤
* │ R     │ 0   │    1 │   0 │    1 │ Write 0       │
* ├───────┼─────┼──────┼─────┼──────┼───────────────┤
* │ R     │ 1   │    1 │   1 │    0 │ Write 1       │
* ├───────┼─────┼──────┼─────┼──────┼───────────────┤
* │ R     │ -   │    0 │   0 │    1 │ Clear         │
* └───────┴─────┴──────┴─────┴──────┴───────────────┘
****************************************
.SUBCKT DFRQQN_DL D CLK RN Q QN VDD VSS
*.PININFO CLK:I D:I RN:I Q:O QN:O VDD:B VSS:B
MN0 n0 CLK VSS VSS sg13_lv_nmos w=2e-07 l=1.3e-07 ng=1
MP0 n0 CLK VDD VDD sg13_lv_pmos w=3e-07 l=1.3e-07 ng=1
MN1 n1 n0 VSS VSS sg13_lv_nmos w=2e-07 l=1.3e-07 ng=1
MP1 n1 n0 VDD VDD sg13_lv_pmos w=3e-07 l=1.3e-07 ng=1
MN2 n2 RN VSS VSS sg13_lv_nmos w=2e-07 l=1.3e-07 ng=1
MN3 n3 D n2 VSS sg13_lv_nmos w=2e-07 l=1.3e-07 ng=1
MP2 n3 RN VDD VDD sg13_lv_pmos w=2.3e-07 l=1.3e-07 ng=1
MP3 n3 D VDD VDD sg13_lv_pmos w=2.3e-07 l=1.3e-07 ng=1
MN4 n4 n3 n5 VSS sg13_lv_nmos w=1.5e-07 l=1.3e-07 ng=1
MN5 n5 n0 VSS VSS sg13_lv_nmos w=1.5e-07 l=1.3e-07 ng=1
MP4 n4 n3 n6 VDD sg13_lv_pmos w=2.3e-07 l=1.3e-07 ng=1
MP5 n6 n1 VDD VDD sg13_lv_pmos w=2.3e-07 l=1.3e-07 ng=1
MN6 n7 n4 VSS VSS sg13_lv_nmos w=1.5e-07 l=1.3e-07 ng=1
MP6 n7 n4 VDD VDD sg13_lv_pmos w=2.3e-07 l=1.3e-07 ng=1
MN7 n4 n1 n8 VSS sg13_lv_nmos w=1.5e-07 l=1.3e-07 ng=1
MN8 n8 n7 VSS VSS sg13_lv_nmos w=1.5e-07 l=1.3e-07 ng=1
MP7 n4 n0 n9 VDD sg13_lv_pmos w=2.3e-07 l=1.3e-07 ng=1
MP8 n9 n7 VDD VDD sg13_lv_pmos w=2.3e-07 l=1.3e-07 ng=1
MN9 n10 n1 n11 VSS sg13_lv_nmos w=2e-07 l=1.3e-07 ng=1
MN10 n11 n7 VSS VSS sg13_lv_nmos w=2e-07 l=1.3e-07 ng=1
MP9 n10 n0 n12 VDD sg13_lv_pmos w=3e-07 l=1.3e-07 ng=1
MP10 n12 n7 VDD VDD sg13_lv_pmos w=3e-07 l=1.3e-07 ng=1
MN11 n13 n10 VSS VSS sg13_lv_nmos w=1.5e-07 l=1.3e-07 ng=1
MP11 n13 n10 VDD VDD sg13_lv_pmos w=2.3e-07 l=1.3e-07 ng=1
MN12 n10 n0 n14 VSS sg13_lv_nmos w=1.5e-07 l=1.3e-07 ng=1
MN13 n14 n13 VSS VSS sg13_lv_nmos w=1.5e-07 l=1.3e-07 ng=1
MP12 n10 n1 n15 VDD sg13_lv_pmos w=1.5e-07 l=1.3e-07 ng=1
MP13 n15 n13 VDD VDD sg13_lv_pmos w=1.5e-07 l=1.3e-07 ng=1
MN14 Q n13 VSS VSS sg13_lv_nmos w=3.2e-07 l=1.3e-07 ng=1
MP14 Q n13 VDD VDD sg13_lv_pmos w=4.9e-07 l=1.3e-07 ng=1
MN15 QN n10 VSS VSS sg13_lv_nmos w=3.2e-07 l=1.3e-07 ng=1
MP15 QN n10 VDD VDD sg13_lv_pmos w=4.9e-07 l=1.3e-07 ng=1
.ENDS

****************************************
* Cell : DFRQ_D1
* Description : D flip-flop with synchronous reset and output Q.
* ┌───────┬─────┬──────┬─────┬───────────────┐
* │ CLK   │ D   │   RN │   Q │ Description   │
* ├───────┼─────┼──────┼─────┼───────────────┤
* │ R     │ 0   │    1 │   0 │ Write 0       │
* ├───────┼─────┼──────┼─────┼───────────────┤
* │ R     │ 1   │    1 │   1 │ Write 1       │
* ├───────┼─────┼──────┼─────┼───────────────┤
* │ R     │ -   │    0 │   0 │ Clear         │
* └───────┴─────┴──────┴─────┴───────────────┘
****************************************
.SUBCKT DFRQ_D1 D CLK RN Q VDD VSS
*.PININFO CLK:I D:I RN:I Q:O VDD:B VSS:B
MN0 n0 CLK VSS VSS sg13_lv_nmos w=3e-07 l=1.3e-07 ng=1
MP0 n0 CLK VDD VDD sg13_lv_pmos w=4.5e-07 l=1.3e-07 ng=1
MN1 n1 n0 VSS VSS sg13_lv_nmos w=2e-07 l=1.3e-07 ng=1
MP1 n1 n0 VDD VDD sg13_lv_pmos w=3e-07 l=1.3e-07 ng=1
MN2 n2 RN VSS VSS sg13_lv_nmos w=2e-07 l=1.3e-07 ng=1
MN3 n3 D n2 VSS sg13_lv_nmos w=2e-07 l=1.3e-07 ng=1
MP2 n3 RN VDD VDD sg13_lv_pmos w=2.3e-07 l=1.3e-07 ng=1
MP3 n3 D VDD VDD sg13_lv_pmos w=2.3e-07 l=1.3e-07 ng=1
MN4 n4 n3 n5 VSS sg13_lv_nmos w=1.5e-07 l=1.3e-07 ng=1
MN5 n5 n0 VSS VSS sg13_lv_nmos w=1.5e-07 l=1.3e-07 ng=1
MP4 n4 n3 n6 VDD sg13_lv_pmos w=2.3e-07 l=1.3e-07 ng=1
MP5 n6 n1 VDD VDD sg13_lv_pmos w=2.3e-07 l=1.3e-07 ng=1
MN6 n7 n4 VSS VSS sg13_lv_nmos w=2e-07 l=1.3e-07 ng=1
MP6 n7 n4 VDD VDD sg13_lv_pmos w=3e-07 l=1.3e-07 ng=1
MN7 n4 n1 n8 VSS sg13_lv_nmos w=1.5e-07 l=1.3e-07 ng=1
MN8 n8 n7 VSS VSS sg13_lv_nmos w=1.5e-07 l=1.3e-07 ng=1
MP7 n4 n0 n9 VDD sg13_lv_pmos w=2.3e-07 l=1.3e-07 ng=1
MP8 n9 n7 VDD VDD sg13_lv_pmos w=2.3e-07 l=1.3e-07 ng=1
MN9 n10 n1 n11 VSS sg13_lv_nmos w=5e-07 l=1.3e-07 ng=1
MN10 n11 n7 VSS VSS sg13_lv_nmos w=5e-07 l=1.3e-07 ng=1
MP9 n10 n0 n12 VDD sg13_lv_pmos w=7.5e-07 l=1.3e-07 ng=1
MP10 n12 n7 VDD VDD sg13_lv_pmos w=7.5e-07 l=1.3e-07 ng=1
MN11 n13 n10 VSS VSS sg13_lv_nmos w=3e-07 l=1.3e-07 ng=1
MP11 n13 n10 VDD VDD sg13_lv_pmos w=4.5e-07 l=1.3e-07 ng=1
MN12 n10 n0 n14 VSS sg13_lv_nmos w=1.5e-07 l=1.3e-07 ng=1
MN13 n14 n13 VSS VSS sg13_lv_nmos w=1.5e-07 l=1.3e-07 ng=1
MP12 n10 n1 n15 VDD sg13_lv_pmos w=1.5e-07 l=1.3e-07 ng=1
MP13 n15 n13 VDD VDD sg13_lv_pmos w=1.5e-07 l=1.3e-07 ng=1
MN14 Q n13 VSS VSS sg13_lv_nmos w=6.4e-07 l=1.3e-07 ng=1
MP14 Q n13 VDD VDD sg13_lv_pmos w=9.8e-07 l=1.3e-07 ng=1
.ENDS

****************************************
* Cell : DFRQ_D2
* Description : D flip-flop with synchronous reset and output Q.
* ┌───────┬─────┬──────┬─────┬───────────────┐
* │ CLK   │ D   │   RN │   Q │ Description   │
* ├───────┼─────┼──────┼─────┼───────────────┤
* │ R     │ 0   │    1 │   0 │ Write 0       │
* ├───────┼─────┼──────┼─────┼───────────────┤
* │ R     │ 1   │    1 │   1 │ Write 1       │
* ├───────┼─────┼──────┼─────┼───────────────┤
* │ R     │ -   │    0 │   0 │ Clear         │
* └───────┴─────┴──────┴─────┴───────────────┘
****************************************
.SUBCKT DFRQ_D2 D CLK RN Q VDD VSS
*.PININFO CLK:I D:I RN:I Q:O VDD:B VSS:B
MN0 n0 CLK VSS VSS sg13_lv_nmos w=4e-07 l=1.3e-07 ng=1
MP0 n0 CLK VDD VDD sg13_lv_pmos w=6e-07 l=1.3e-07 ng=1
MN1 n1 n0 VSS VSS sg13_lv_nmos w=3e-07 l=1.3e-07 ng=1
MP1 n1 n0 VDD VDD sg13_lv_pmos w=4.5e-07 l=1.3e-07 ng=1
MN2 n2 RN VSS VSS sg13_lv_nmos w=3e-07 l=1.3e-07 ng=1
MN3 n3 D n2 VSS sg13_lv_nmos w=3e-07 l=1.3e-07 ng=1
MP2 n3 RN VDD VDD sg13_lv_pmos w=3.3e-07 l=1.3e-07 ng=1
MP3 n3 D VDD VDD sg13_lv_pmos w=3.3e-07 l=1.3e-07 ng=1
MN4 n4 n0 n5 VSS sg13_lv_nmos w=2.5e-07 l=1.3e-07 ng=1
MN5 n5 n3 VSS VSS sg13_lv_nmos w=2.5e-07 l=1.3e-07 ng=1
MP4 n4 n1 n6 VDD sg13_lv_pmos w=3.8e-07 l=1.3e-07 ng=1
MP5 n6 n3 VDD VDD sg13_lv_pmos w=3.8e-07 l=1.3e-07 ng=1
MN6 n7 n4 VSS VSS sg13_lv_nmos w=3e-07 l=1.3e-07 ng=1
MP6 n7 n4 VDD VDD sg13_lv_pmos w=4.5e-07 l=1.3e-07 ng=1
MN7 n4 n1 n8 VSS sg13_lv_nmos w=1.5e-07 l=1.3e-07 ng=1
MN8 n8 n7 VSS VSS sg13_lv_nmos w=1.5e-07 l=1.3e-07 ng=1
MP7 n4 n0 n9 VDD sg13_lv_pmos w=2.3e-07 l=1.3e-07 ng=1
MP8 n9 n7 VDD VDD sg13_lv_pmos w=2.3e-07 l=1.3e-07 ng=1
MN9 n10 n1 n11 VSS sg13_lv_nmos w=9.2e-07 l=1.3e-07 ng=1
MN10 n11 n7 VSS VSS sg13_lv_nmos w=9.2e-07 l=1.3e-07 ng=1
MP9 n10 n0 n12 VDD sg13_lv_pmos w=1.38e-06 l=1.3e-07 ng=1
MP10 n12 n7 VDD VDD sg13_lv_pmos w=1.38e-06 l=1.3e-07 ng=1
MN11 n13 n10 VSS VSS sg13_lv_nmos w=5e-07 l=1.3e-07 ng=1
MP11 n13 n10 VDD VDD sg13_lv_pmos w=7.5e-07 l=1.3e-07 ng=1
MN12 n10 n0 n14 VSS sg13_lv_nmos w=1.5e-07 l=1.3e-07 ng=1
MN13 n14 n13 VSS VSS sg13_lv_nmos w=1.5e-07 l=1.3e-07 ng=1
MP12 n10 n1 n15 VDD sg13_lv_pmos w=1.5e-07 l=1.3e-07 ng=1
MP13 n15 n13 VDD VDD sg13_lv_pmos w=1.5e-07 l=1.3e-07 ng=1
MN14 Q n13 VSS VSS sg13_lv_nmos w=1.07e-06 l=1.3e-07 ng=1
MP14 Q n13 VDD VDD sg13_lv_pmos w=1.6e-06 l=1.3e-07 ng=1
.ENDS

****************************************
* Cell : DFRQ_DL
* Description : D flip-flop with synchronous reset and output Q.
* ┌───────┬─────┬──────┬─────┬───────────────┐
* │ CLK   │ D   │   RN │   Q │ Description   │
* ├───────┼─────┼──────┼─────┼───────────────┤
* │ R     │ 0   │    1 │   0 │ Write 0       │
* ├───────┼─────┼──────┼─────┼───────────────┤
* │ R     │ 1   │    1 │   1 │ Write 1       │
* ├───────┼─────┼──────┼─────┼───────────────┤
* │ R     │ -   │    0 │   0 │ Clear         │
* └───────┴─────┴──────┴─────┴───────────────┘
****************************************
.SUBCKT DFRQ_DL D CLK RN Q VDD VSS
*.PININFO CLK:I D:I RN:I Q:O VDD:B VSS:B
MN0 n0 CLK VSS VSS sg13_lv_nmos w=2e-07 l=1.3e-07 ng=1
MP0 n0 CLK VDD VDD sg13_lv_pmos w=3e-07 l=1.3e-07 ng=1
MN1 n1 n0 VSS VSS sg13_lv_nmos w=2e-07 l=1.3e-07 ng=1
MP1 n1 n0 VDD VDD sg13_lv_pmos w=3e-07 l=1.3e-07 ng=1
MN2 n2 RN VSS VSS sg13_lv_nmos w=2e-07 l=1.3e-07 ng=1
MN3 n3 D n2 VSS sg13_lv_nmos w=2e-07 l=1.3e-07 ng=1
MP2 n3 RN VDD VDD sg13_lv_pmos w=2.3e-07 l=1.3e-07 ng=1
MP3 n3 D VDD VDD sg13_lv_pmos w=2.3e-07 l=1.3e-07 ng=1
MN4 n4 n3 n5 VSS sg13_lv_nmos w=1.5e-07 l=1.3e-07 ng=1
MN5 n5 n0 VSS VSS sg13_lv_nmos w=1.5e-07 l=1.3e-07 ng=1
MP4 n4 n3 n6 VDD sg13_lv_pmos w=2.3e-07 l=1.3e-07 ng=1
MP5 n6 n1 VDD VDD sg13_lv_pmos w=2.3e-07 l=1.3e-07 ng=1
MN6 n7 n4 VSS VSS sg13_lv_nmos w=1.5e-07 l=1.3e-07 ng=1
MP6 n7 n4 VDD VDD sg13_lv_pmos w=2.3e-07 l=1.3e-07 ng=1
MN7 n4 n1 n8 VSS sg13_lv_nmos w=1.5e-07 l=1.3e-07 ng=1
MN8 n8 n7 VSS VSS sg13_lv_nmos w=1.5e-07 l=1.3e-07 ng=1
MP7 n4 n0 n9 VDD sg13_lv_pmos w=2.3e-07 l=1.3e-07 ng=1
MP8 n9 n7 VDD VDD sg13_lv_pmos w=2.3e-07 l=1.3e-07 ng=1
MN9 n10 n1 n11 VSS sg13_lv_nmos w=2e-07 l=1.3e-07 ng=1
MN10 n11 n7 VSS VSS sg13_lv_nmos w=2e-07 l=1.3e-07 ng=1
MP9 n10 n0 n12 VDD sg13_lv_pmos w=3e-07 l=1.3e-07 ng=1
MP10 n12 n7 VDD VDD sg13_lv_pmos w=3e-07 l=1.3e-07 ng=1
MN11 n13 n10 VSS VSS sg13_lv_nmos w=1.5e-07 l=1.3e-07 ng=1
MP11 n13 n10 VDD VDD sg13_lv_pmos w=2.3e-07 l=1.3e-07 ng=1
MN12 n10 n0 n14 VSS sg13_lv_nmos w=1.5e-07 l=1.3e-07 ng=1
MN13 n14 n13 VSS VSS sg13_lv_nmos w=1.5e-07 l=1.3e-07 ng=1
MP12 n10 n1 n15 VDD sg13_lv_pmos w=1.5e-07 l=1.3e-07 ng=1
MP13 n15 n13 VDD VDD sg13_lv_pmos w=1.5e-07 l=1.3e-07 ng=1
MN14 Q n13 VSS VSS sg13_lv_nmos w=3.2e-07 l=1.3e-07 ng=1
MP14 Q n13 VDD VDD sg13_lv_pmos w=4.9e-07 l=1.3e-07 ng=1
.ENDS

****************************************
* Cell : DFSQN_D1
* Description : D flip-flop with synchronous set and output QN.
* ┌───────┬─────┬─────┬──────┬───────────────┐
* │ CLK   │ D   │   S │   QN │ Description   │
* ├───────┼─────┼─────┼──────┼───────────────┤
* │ R     │ 0   │   0 │    1 │ Write 0       │
* ├───────┼─────┼─────┼──────┼───────────────┤
* │ R     │ 1   │   0 │    0 │ Write 1       │
* ├───────┼─────┼─────┼──────┼───────────────┤
* │ R     │ -   │   1 │    0 │ Set           │
* └───────┴─────┴─────┴──────┴───────────────┘
****************************************
.SUBCKT DFSQN_D1 D CLK S QN VDD VSS
*.PININFO CLK:I D:I S:I QN:O VDD:B VSS:B
MN0 n0 CLK VSS VSS sg13_lv_nmos w=3e-07 l=1.3e-07 ng=1
MP0 n0 CLK VDD VDD sg13_lv_pmos w=4.5e-07 l=1.3e-07 ng=1
MN1 n1 n0 VSS VSS sg13_lv_nmos w=2e-07 l=1.3e-07 ng=1
MP1 n1 n0 VDD VDD sg13_lv_pmos w=3e-07 l=1.3e-07 ng=1
MN2 n2 S VSS VSS sg13_lv_nmos w=1.5e-07 l=1.3e-07 ng=1
MN3 n2 D VSS VSS sg13_lv_nmos w=1.5e-07 l=1.3e-07 ng=1
MP2 n3 S VDD VDD sg13_lv_pmos w=3e-07 l=1.3e-07 ng=1
MP3 n2 D n3 VDD sg13_lv_pmos w=3e-07 l=1.3e-07 ng=1
MN4 n4 n2 n5 VSS sg13_lv_nmos w=1.5e-07 l=1.3e-07 ng=1
MN5 n5 n0 VSS VSS sg13_lv_nmos w=1.5e-07 l=1.3e-07 ng=1
MP4 n4 n2 n6 VDD sg13_lv_pmos w=2.3e-07 l=1.3e-07 ng=1
MP5 n6 n1 VDD VDD sg13_lv_pmos w=2.3e-07 l=1.3e-07 ng=1
MN6 n7 n4 VSS VSS sg13_lv_nmos w=2e-07 l=1.3e-07 ng=1
MP6 n7 n4 VDD VDD sg13_lv_pmos w=3e-07 l=1.3e-07 ng=1
MN7 n4 n1 n8 VSS sg13_lv_nmos w=1.5e-07 l=1.3e-07 ng=1
MN8 n8 n7 VSS VSS sg13_lv_nmos w=1.5e-07 l=1.3e-07 ng=1
MP7 n4 n0 n9 VDD sg13_lv_pmos w=2.3e-07 l=1.3e-07 ng=1
MP8 n9 n7 VDD VDD sg13_lv_pmos w=2.3e-07 l=1.3e-07 ng=1
MN9 n10 n1 n11 VSS sg13_lv_nmos w=5e-07 l=1.3e-07 ng=1
MN10 n11 n7 VSS VSS sg13_lv_nmos w=5e-07 l=1.3e-07 ng=1
MP9 n10 n0 n12 VDD sg13_lv_pmos w=7.5e-07 l=1.3e-07 ng=1
MP10 n12 n7 VDD VDD sg13_lv_pmos w=7.5e-07 l=1.3e-07 ng=1
MN11 n13 n10 VSS VSS sg13_lv_nmos w=3e-07 l=1.3e-07 ng=1
MP11 n13 n10 VDD VDD sg13_lv_pmos w=4.5e-07 l=1.3e-07 ng=1
MN12 n10 n0 n14 VSS sg13_lv_nmos w=1.5e-07 l=1.3e-07 ng=1
MN13 n14 n13 VSS VSS sg13_lv_nmos w=1.5e-07 l=1.3e-07 ng=1
MP12 n10 n1 n15 VDD sg13_lv_pmos w=1.5e-07 l=1.3e-07 ng=1
MP13 n15 n13 VDD VDD sg13_lv_pmos w=1.5e-07 l=1.3e-07 ng=1
MN14 QN n10 VSS VSS sg13_lv_nmos w=6.4e-07 l=1.3e-07 ng=1
MP14 QN n10 VDD VDD sg13_lv_pmos w=9.8e-07 l=1.3e-07 ng=1
.ENDS

****************************************
* Cell : DFSQN_D2
* Description : D flip-flop with synchronous set and output QN.
* ┌───────┬─────┬─────┬──────┬───────────────┐
* │ CLK   │ D   │   S │   QN │ Description   │
* ├───────┼─────┼─────┼──────┼───────────────┤
* │ R     │ 0   │   0 │    1 │ Write 0       │
* ├───────┼─────┼─────┼──────┼───────────────┤
* │ R     │ 1   │   0 │    0 │ Write 1       │
* ├───────┼─────┼─────┼──────┼───────────────┤
* │ R     │ -   │   1 │    0 │ Set           │
* └───────┴─────┴─────┴──────┴───────────────┘
****************************************
.SUBCKT DFSQN_D2 D CLK S QN VDD VSS
*.PININFO CLK:I D:I S:I QN:O VDD:B VSS:B
MN0 n0 CLK VSS VSS sg13_lv_nmos w=4e-07 l=1.3e-07 ng=1
MP0 n0 CLK VDD VDD sg13_lv_pmos w=6e-07 l=1.3e-07 ng=1
MN1 n1 n0 VSS VSS sg13_lv_nmos w=3e-07 l=1.3e-07 ng=1
MP1 n1 n0 VDD VDD sg13_lv_pmos w=4.5e-07 l=1.3e-07 ng=1
MN2 n2 S VSS VSS sg13_lv_nmos w=2e-07 l=1.3e-07 ng=1
MN3 n2 D VSS VSS sg13_lv_nmos w=2e-07 l=1.3e-07 ng=1
MP2 n3 S VDD VDD sg13_lv_pmos w=4.5e-07 l=1.3e-07 ng=1
MP3 n2 D n3 VDD sg13_lv_pmos w=4.5e-07 l=1.3e-07 ng=1
MN4 n4 n0 n5 VSS sg13_lv_nmos w=2.5e-07 l=1.3e-07 ng=1
MN5 n5 n2 VSS VSS sg13_lv_nmos w=2.5e-07 l=1.3e-07 ng=1
MP4 n4 n1 n6 VDD sg13_lv_pmos w=3.8e-07 l=1.3e-07 ng=1
MP5 n6 n2 VDD VDD sg13_lv_pmos w=3.8e-07 l=1.3e-07 ng=1
MN6 n7 n4 VSS VSS sg13_lv_nmos w=3e-07 l=1.3e-07 ng=1
MP6 n7 n4 VDD VDD sg13_lv_pmos w=4.5e-07 l=1.3e-07 ng=1
MN7 n4 n1 n8 VSS sg13_lv_nmos w=1.5e-07 l=1.3e-07 ng=1
MN8 n8 n7 VSS VSS sg13_lv_nmos w=1.5e-07 l=1.3e-07 ng=1
MP7 n4 n0 n9 VDD sg13_lv_pmos w=2.3e-07 l=1.3e-07 ng=1
MP8 n9 n7 VDD VDD sg13_lv_pmos w=2.3e-07 l=1.3e-07 ng=1
MN9 n10 n1 n11 VSS sg13_lv_nmos w=9.2e-07 l=1.3e-07 ng=1
MN10 n11 n7 VSS VSS sg13_lv_nmos w=9.2e-07 l=1.3e-07 ng=1
MP9 n10 n0 n12 VDD sg13_lv_pmos w=1.38e-06 l=1.3e-07 ng=1
MP10 n12 n7 VDD VDD sg13_lv_pmos w=1.38e-06 l=1.3e-07 ng=1
MN11 n13 n10 VSS VSS sg13_lv_nmos w=5e-07 l=1.3e-07 ng=1
MP11 n13 n10 VDD VDD sg13_lv_pmos w=7.5e-07 l=1.3e-07 ng=1
MN12 n10 n0 n14 VSS sg13_lv_nmos w=1.5e-07 l=1.3e-07 ng=1
MN13 n14 n13 VSS VSS sg13_lv_nmos w=1.5e-07 l=1.3e-07 ng=1
MP12 n10 n1 n15 VDD sg13_lv_pmos w=1.5e-07 l=1.3e-07 ng=1
MP13 n15 n13 VDD VDD sg13_lv_pmos w=1.5e-07 l=1.3e-07 ng=1
MN14 QN n10 VSS VSS sg13_lv_nmos w=1.07e-06 l=1.3e-07 ng=1
MP14 QN n10 VDD VDD sg13_lv_pmos w=1.6e-06 l=1.3e-07 ng=1
.ENDS

****************************************
* Cell : DFSQN_DL
* Description : D flip-flop with synchronous set and output QN.
* ┌───────┬─────┬─────┬──────┬───────────────┐
* │ CLK   │ D   │   S │   QN │ Description   │
* ├───────┼─────┼─────┼──────┼───────────────┤
* │ R     │ 0   │   0 │    1 │ Write 0       │
* ├───────┼─────┼─────┼──────┼───────────────┤
* │ R     │ 1   │   0 │    0 │ Write 1       │
* ├───────┼─────┼─────┼──────┼───────────────┤
* │ R     │ -   │   1 │    0 │ Set           │
* └───────┴─────┴─────┴──────┴───────────────┘
****************************************
.SUBCKT DFSQN_DL D CLK S QN VDD VSS
*.PININFO CLK:I D:I S:I QN:O VDD:B VSS:B
MN0 n0 CLK VSS VSS sg13_lv_nmos w=2e-07 l=1.3e-07 ng=1
MP0 n0 CLK VDD VDD sg13_lv_pmos w=3e-07 l=1.3e-07 ng=1
MN1 n1 n0 VSS VSS sg13_lv_nmos w=2e-07 l=1.3e-07 ng=1
MP1 n1 n0 VDD VDD sg13_lv_pmos w=3e-07 l=1.3e-07 ng=1
MN2 n2 S VSS VSS sg13_lv_nmos w=1.5e-07 l=1.3e-07 ng=1
MN3 n2 D VSS VSS sg13_lv_nmos w=1.5e-07 l=1.3e-07 ng=1
MP2 n3 S VDD VDD sg13_lv_pmos w=2.3e-07 l=1.3e-07 ng=1
MP3 n2 D n3 VDD sg13_lv_pmos w=2.3e-07 l=1.3e-07 ng=1
MN4 n4 n2 n5 VSS sg13_lv_nmos w=1.5e-07 l=1.3e-07 ng=1
MN5 n5 n0 VSS VSS sg13_lv_nmos w=1.5e-07 l=1.3e-07 ng=1
MP4 n4 n2 n6 VDD sg13_lv_pmos w=2.3e-07 l=1.3e-07 ng=1
MP5 n6 n1 VDD VDD sg13_lv_pmos w=2.3e-07 l=1.3e-07 ng=1
MN6 n7 n4 VSS VSS sg13_lv_nmos w=1.5e-07 l=1.3e-07 ng=1
MP6 n7 n4 VDD VDD sg13_lv_pmos w=2.3e-07 l=1.3e-07 ng=1
MN7 n4 n1 n8 VSS sg13_lv_nmos w=1.5e-07 l=1.3e-07 ng=1
MN8 n8 n7 VSS VSS sg13_lv_nmos w=1.5e-07 l=1.3e-07 ng=1
MP7 n4 n0 n9 VDD sg13_lv_pmos w=2.3e-07 l=1.3e-07 ng=1
MP8 n9 n7 VDD VDD sg13_lv_pmos w=2.3e-07 l=1.3e-07 ng=1
MN9 n10 n1 n11 VSS sg13_lv_nmos w=2e-07 l=1.3e-07 ng=1
MN10 n11 n7 VSS VSS sg13_lv_nmos w=2e-07 l=1.3e-07 ng=1
MP9 n10 n0 n12 VDD sg13_lv_pmos w=3e-07 l=1.3e-07 ng=1
MP10 n12 n7 VDD VDD sg13_lv_pmos w=3e-07 l=1.3e-07 ng=1
MN11 n13 n10 VSS VSS sg13_lv_nmos w=1.5e-07 l=1.3e-07 ng=1
MP11 n13 n10 VDD VDD sg13_lv_pmos w=2.3e-07 l=1.3e-07 ng=1
MN12 n10 n0 n14 VSS sg13_lv_nmos w=1.5e-07 l=1.3e-07 ng=1
MN13 n14 n13 VSS VSS sg13_lv_nmos w=1.5e-07 l=1.3e-07 ng=1
MP12 n10 n1 n15 VDD sg13_lv_pmos w=1.5e-07 l=1.3e-07 ng=1
MP13 n15 n13 VDD VDD sg13_lv_pmos w=1.5e-07 l=1.3e-07 ng=1
MN14 QN n10 VSS VSS sg13_lv_nmos w=3.2e-07 l=1.3e-07 ng=1
MP14 QN n10 VDD VDD sg13_lv_pmos w=4.9e-07 l=1.3e-07 ng=1
.ENDS

****************************************
* Cell : DFSQQN_D1
* Description : D flip-flop with synchronous set and outputs Q and QN.
* ┌───────┬─────┬─────┬─────┬──────┬───────────────┐
* │ CLK   │ D   │   S │   Q │   QN │ Description   │
* ├───────┼─────┼─────┼─────┼──────┼───────────────┤
* │ R     │ 0   │   0 │   0 │    1 │ Write 0       │
* ├───────┼─────┼─────┼─────┼──────┼───────────────┤
* │ R     │ 1   │   0 │   1 │    0 │ Write 1       │
* ├───────┼─────┼─────┼─────┼──────┼───────────────┤
* │ R     │ -   │   1 │   1 │    0 │ Set           │
* └───────┴─────┴─────┴─────┴──────┴───────────────┘
****************************************
.SUBCKT DFSQQN_D1 D CLK S Q QN VDD VSS
*.PININFO CLK:I D:I S:I Q:O QN:O VDD:B VSS:B
MN0 n0 CLK VSS VSS sg13_lv_nmos w=3e-07 l=1.3e-07 ng=1
MP0 n0 CLK VDD VDD sg13_lv_pmos w=4.5e-07 l=1.3e-07 ng=1
MN1 n1 n0 VSS VSS sg13_lv_nmos w=2e-07 l=1.3e-07 ng=1
MP1 n1 n0 VDD VDD sg13_lv_pmos w=3e-07 l=1.3e-07 ng=1
MN2 n2 S VSS VSS sg13_lv_nmos w=1.5e-07 l=1.3e-07 ng=1
MN3 n2 D VSS VSS sg13_lv_nmos w=1.5e-07 l=1.3e-07 ng=1
MP2 n3 S VDD VDD sg13_lv_pmos w=3e-07 l=1.3e-07 ng=1
MP3 n2 D n3 VDD sg13_lv_pmos w=3e-07 l=1.3e-07 ng=1
MN4 n4 n2 n5 VSS sg13_lv_nmos w=1.5e-07 l=1.3e-07 ng=1
MN5 n5 n0 VSS VSS sg13_lv_nmos w=1.5e-07 l=1.3e-07 ng=1
MP4 n4 n2 n6 VDD sg13_lv_pmos w=2.3e-07 l=1.3e-07 ng=1
MP5 n6 n1 VDD VDD sg13_lv_pmos w=2.3e-07 l=1.3e-07 ng=1
MN6 n7 n4 VSS VSS sg13_lv_nmos w=2e-07 l=1.3e-07 ng=1
MP6 n7 n4 VDD VDD sg13_lv_pmos w=3e-07 l=1.3e-07 ng=1
MN7 n4 n1 n8 VSS sg13_lv_nmos w=1.5e-07 l=1.3e-07 ng=1
MN8 n8 n7 VSS VSS sg13_lv_nmos w=1.5e-07 l=1.3e-07 ng=1
MP7 n4 n0 n9 VDD sg13_lv_pmos w=2.3e-07 l=1.3e-07 ng=1
MP8 n9 n7 VDD VDD sg13_lv_pmos w=2.3e-07 l=1.3e-07 ng=1
MN9 n10 n1 n11 VSS sg13_lv_nmos w=5e-07 l=1.3e-07 ng=1
MN10 n11 n7 VSS VSS sg13_lv_nmos w=5e-07 l=1.3e-07 ng=1
MP9 n10 n0 n12 VDD sg13_lv_pmos w=7.5e-07 l=1.3e-07 ng=1
MP10 n12 n7 VDD VDD sg13_lv_pmos w=7.5e-07 l=1.3e-07 ng=1
MN11 n13 n10 VSS VSS sg13_lv_nmos w=3e-07 l=1.3e-07 ng=1
MP11 n13 n10 VDD VDD sg13_lv_pmos w=4.5e-07 l=1.3e-07 ng=1
MN12 n10 n0 n14 VSS sg13_lv_nmos w=1.5e-07 l=1.3e-07 ng=1
MN13 n14 n13 VSS VSS sg13_lv_nmos w=1.5e-07 l=1.3e-07 ng=1
MP12 n10 n1 n15 VDD sg13_lv_pmos w=1.5e-07 l=1.3e-07 ng=1
MP13 n15 n13 VDD VDD sg13_lv_pmos w=1.5e-07 l=1.3e-07 ng=1
MN14 Q n13 VSS VSS sg13_lv_nmos w=6.4e-07 l=1.3e-07 ng=1
MP14 Q n13 VDD VDD sg13_lv_pmos w=9.8e-07 l=1.3e-07 ng=1
MN15 QN n10 VSS VSS sg13_lv_nmos w=6.4e-07 l=1.3e-07 ng=1
MP15 QN n10 VDD VDD sg13_lv_pmos w=9.8e-07 l=1.3e-07 ng=1
.ENDS

****************************************
* Cell : DFSQQN_D2
* Description : D flip-flop with synchronous set and outputs Q and QN.
* ┌───────┬─────┬─────┬─────┬──────┬───────────────┐
* │ CLK   │ D   │   S │   Q │   QN │ Description   │
* ├───────┼─────┼─────┼─────┼──────┼───────────────┤
* │ R     │ 0   │   0 │   0 │    1 │ Write 0       │
* ├───────┼─────┼─────┼─────┼──────┼───────────────┤
* │ R     │ 1   │   0 │   1 │    0 │ Write 1       │
* ├───────┼─────┼─────┼─────┼──────┼───────────────┤
* │ R     │ -   │   1 │   1 │    0 │ Set           │
* └───────┴─────┴─────┴─────┴──────┴───────────────┘
****************************************
.SUBCKT DFSQQN_D2 D CLK S Q QN VDD VSS
*.PININFO CLK:I D:I S:I Q:O QN:O VDD:B VSS:B
MN0 n0 CLK VSS VSS sg13_lv_nmos w=4e-07 l=1.3e-07 ng=1
MP0 n0 CLK VDD VDD sg13_lv_pmos w=6e-07 l=1.3e-07 ng=1
MN1 n1 n0 VSS VSS sg13_lv_nmos w=3e-07 l=1.3e-07 ng=1
MP1 n1 n0 VDD VDD sg13_lv_pmos w=4.5e-07 l=1.3e-07 ng=1
MN2 n2 S VSS VSS sg13_lv_nmos w=2e-07 l=1.3e-07 ng=1
MN3 n2 D VSS VSS sg13_lv_nmos w=2e-07 l=1.3e-07 ng=1
MP2 n3 S VDD VDD sg13_lv_pmos w=4.5e-07 l=1.3e-07 ng=1
MP3 n2 D n3 VDD sg13_lv_pmos w=4.5e-07 l=1.3e-07 ng=1
MN4 n4 n0 n5 VSS sg13_lv_nmos w=2.5e-07 l=1.3e-07 ng=1
MN5 n5 n2 VSS VSS sg13_lv_nmos w=2.5e-07 l=1.3e-07 ng=1
MP4 n4 n1 n6 VDD sg13_lv_pmos w=3.8e-07 l=1.3e-07 ng=1
MP5 n6 n2 VDD VDD sg13_lv_pmos w=3.8e-07 l=1.3e-07 ng=1
MN6 n7 n4 VSS VSS sg13_lv_nmos w=3e-07 l=1.3e-07 ng=1
MP6 n7 n4 VDD VDD sg13_lv_pmos w=4.5e-07 l=1.3e-07 ng=1
MN7 n4 n1 n8 VSS sg13_lv_nmos w=1.5e-07 l=1.3e-07 ng=1
MN8 n8 n7 VSS VSS sg13_lv_nmos w=1.5e-07 l=1.3e-07 ng=1
MP7 n4 n0 n9 VDD sg13_lv_pmos w=2.3e-07 l=1.3e-07 ng=1
MP8 n9 n7 VDD VDD sg13_lv_pmos w=2.3e-07 l=1.3e-07 ng=1
MN9 n10 n1 n11 VSS sg13_lv_nmos w=9.2e-07 l=1.3e-07 ng=1
MN10 n11 n7 VSS VSS sg13_lv_nmos w=9.2e-07 l=1.3e-07 ng=1
MP9 n10 n0 n12 VDD sg13_lv_pmos w=1.38e-06 l=1.3e-07 ng=1
MP10 n12 n7 VDD VDD sg13_lv_pmos w=1.38e-06 l=1.3e-07 ng=1
MN11 n13 n10 VSS VSS sg13_lv_nmos w=5e-07 l=1.3e-07 ng=1
MP11 n13 n10 VDD VDD sg13_lv_pmos w=7.5e-07 l=1.3e-07 ng=1
MN12 n10 n0 n14 VSS sg13_lv_nmos w=1.5e-07 l=1.3e-07 ng=1
MN13 n14 n13 VSS VSS sg13_lv_nmos w=1.5e-07 l=1.3e-07 ng=1
MP12 n10 n1 n15 VDD sg13_lv_pmos w=1.5e-07 l=1.3e-07 ng=1
MP13 n15 n13 VDD VDD sg13_lv_pmos w=1.5e-07 l=1.3e-07 ng=1
MN14 Q n13 VSS VSS sg13_lv_nmos w=1.07e-06 l=1.3e-07 ng=1
MP14 Q n13 VDD VDD sg13_lv_pmos w=1.6e-06 l=1.3e-07 ng=1
MN15 QN n10 VSS VSS sg13_lv_nmos w=1.07e-06 l=1.3e-07 ng=1
MP15 QN n10 VDD VDD sg13_lv_pmos w=1.6e-06 l=1.3e-07 ng=1
.ENDS

****************************************
* Cell : DFSQQN_DL
* Description : D flip-flop with synchronous set and outputs Q and QN.
* ┌───────┬─────┬─────┬─────┬──────┬───────────────┐
* │ CLK   │ D   │   S │   Q │   QN │ Description   │
* ├───────┼─────┼─────┼─────┼──────┼───────────────┤
* │ R     │ 0   │   0 │   0 │    1 │ Write 0       │
* ├───────┼─────┼─────┼─────┼──────┼───────────────┤
* │ R     │ 1   │   0 │   1 │    0 │ Write 1       │
* ├───────┼─────┼─────┼─────┼──────┼───────────────┤
* │ R     │ -   │   1 │   1 │    0 │ Set           │
* └───────┴─────┴─────┴─────┴──────┴───────────────┘
****************************************
.SUBCKT DFSQQN_DL D CLK S Q QN VDD VSS
*.PININFO CLK:I D:I S:I Q:O QN:O VDD:B VSS:B
MN0 n0 CLK VSS VSS sg13_lv_nmos w=2e-07 l=1.3e-07 ng=1
MP0 n0 CLK VDD VDD sg13_lv_pmos w=3e-07 l=1.3e-07 ng=1
MN1 n1 n0 VSS VSS sg13_lv_nmos w=2e-07 l=1.3e-07 ng=1
MP1 n1 n0 VDD VDD sg13_lv_pmos w=3e-07 l=1.3e-07 ng=1
MN2 n2 S VSS VSS sg13_lv_nmos w=1.5e-07 l=1.3e-07 ng=1
MN3 n2 D VSS VSS sg13_lv_nmos w=1.5e-07 l=1.3e-07 ng=1
MP2 n3 S VDD VDD sg13_lv_pmos w=2.3e-07 l=1.3e-07 ng=1
MP3 n2 D n3 VDD sg13_lv_pmos w=2.3e-07 l=1.3e-07 ng=1
MN4 n4 n2 n5 VSS sg13_lv_nmos w=1.5e-07 l=1.3e-07 ng=1
MN5 n5 n0 VSS VSS sg13_lv_nmos w=1.5e-07 l=1.3e-07 ng=1
MP4 n4 n2 n6 VDD sg13_lv_pmos w=2.3e-07 l=1.3e-07 ng=1
MP5 n6 n1 VDD VDD sg13_lv_pmos w=2.3e-07 l=1.3e-07 ng=1
MN6 n7 n4 VSS VSS sg13_lv_nmos w=1.5e-07 l=1.3e-07 ng=1
MP6 n7 n4 VDD VDD sg13_lv_pmos w=2.3e-07 l=1.3e-07 ng=1
MN7 n4 n1 n8 VSS sg13_lv_nmos w=1.5e-07 l=1.3e-07 ng=1
MN8 n8 n7 VSS VSS sg13_lv_nmos w=1.5e-07 l=1.3e-07 ng=1
MP7 n4 n0 n9 VDD sg13_lv_pmos w=2.3e-07 l=1.3e-07 ng=1
MP8 n9 n7 VDD VDD sg13_lv_pmos w=2.3e-07 l=1.3e-07 ng=1
MN9 n10 n1 n11 VSS sg13_lv_nmos w=2e-07 l=1.3e-07 ng=1
MN10 n11 n7 VSS VSS sg13_lv_nmos w=2e-07 l=1.3e-07 ng=1
MP9 n10 n0 n12 VDD sg13_lv_pmos w=3e-07 l=1.3e-07 ng=1
MP10 n12 n7 VDD VDD sg13_lv_pmos w=3e-07 l=1.3e-07 ng=1
MN11 n13 n10 VSS VSS sg13_lv_nmos w=1.5e-07 l=1.3e-07 ng=1
MP11 n13 n10 VDD VDD sg13_lv_pmos w=2.3e-07 l=1.3e-07 ng=1
MN12 n10 n0 n14 VSS sg13_lv_nmos w=1.5e-07 l=1.3e-07 ng=1
MN13 n14 n13 VSS VSS sg13_lv_nmos w=1.5e-07 l=1.3e-07 ng=1
MP12 n10 n1 n15 VDD sg13_lv_pmos w=1.5e-07 l=1.3e-07 ng=1
MP13 n15 n13 VDD VDD sg13_lv_pmos w=1.5e-07 l=1.3e-07 ng=1
MN14 Q n13 VSS VSS sg13_lv_nmos w=3.2e-07 l=1.3e-07 ng=1
MP14 Q n13 VDD VDD sg13_lv_pmos w=4.9e-07 l=1.3e-07 ng=1
MN15 QN n10 VSS VSS sg13_lv_nmos w=3.2e-07 l=1.3e-07 ng=1
MP15 QN n10 VDD VDD sg13_lv_pmos w=4.9e-07 l=1.3e-07 ng=1
.ENDS

****************************************
* Cell : DFSQ_D1
* Description : D flip-flop with synchronous set and output Q.
* ┌───────┬─────┬─────┬─────┬───────────────┐
* │ CLK   │ D   │   S │   Q │ Description   │
* ├───────┼─────┼─────┼─────┼───────────────┤
* │ R     │ 0   │   0 │   0 │ Write 0       │
* ├───────┼─────┼─────┼─────┼───────────────┤
* │ R     │ 1   │   0 │   1 │ Write 1       │
* ├───────┼─────┼─────┼─────┼───────────────┤
* │ R     │ -   │   1 │   1 │ Set           │
* └───────┴─────┴─────┴─────┴───────────────┘
****************************************
.SUBCKT DFSQ_D1 D CLK S Q VDD VSS
*.PININFO CLK:I D:I S:I Q:O VDD:B VSS:B
MN0 n0 CLK VSS VSS sg13_lv_nmos w=3e-07 l=1.3e-07 ng=1
MP0 n0 CLK VDD VDD sg13_lv_pmos w=4.5e-07 l=1.3e-07 ng=1
MN1 n1 n0 VSS VSS sg13_lv_nmos w=2e-07 l=1.3e-07 ng=1
MP1 n1 n0 VDD VDD sg13_lv_pmos w=3e-07 l=1.3e-07 ng=1
MN2 n2 S VSS VSS sg13_lv_nmos w=1.5e-07 l=1.3e-07 ng=1
MN3 n2 D VSS VSS sg13_lv_nmos w=1.5e-07 l=1.3e-07 ng=1
MP2 n3 S VDD VDD sg13_lv_pmos w=3e-07 l=1.3e-07 ng=1
MP3 n2 D n3 VDD sg13_lv_pmos w=3e-07 l=1.3e-07 ng=1
MN4 n4 n2 n5 VSS sg13_lv_nmos w=1.5e-07 l=1.3e-07 ng=1
MN5 n5 n0 VSS VSS sg13_lv_nmos w=1.5e-07 l=1.3e-07 ng=1
MP4 n4 n2 n6 VDD sg13_lv_pmos w=2.3e-07 l=1.3e-07 ng=1
MP5 n6 n1 VDD VDD sg13_lv_pmos w=2.3e-07 l=1.3e-07 ng=1
MN6 n7 n4 VSS VSS sg13_lv_nmos w=2e-07 l=1.3e-07 ng=1
MP6 n7 n4 VDD VDD sg13_lv_pmos w=3e-07 l=1.3e-07 ng=1
MN7 n4 n1 n8 VSS sg13_lv_nmos w=1.5e-07 l=1.3e-07 ng=1
MN8 n8 n7 VSS VSS sg13_lv_nmos w=1.5e-07 l=1.3e-07 ng=1
MP7 n4 n0 n9 VDD sg13_lv_pmos w=2.3e-07 l=1.3e-07 ng=1
MP8 n9 n7 VDD VDD sg13_lv_pmos w=2.3e-07 l=1.3e-07 ng=1
MN9 n10 n1 n11 VSS sg13_lv_nmos w=5e-07 l=1.3e-07 ng=1
MN10 n11 n7 VSS VSS sg13_lv_nmos w=5e-07 l=1.3e-07 ng=1
MP9 n10 n0 n12 VDD sg13_lv_pmos w=7.5e-07 l=1.3e-07 ng=1
MP10 n12 n7 VDD VDD sg13_lv_pmos w=7.5e-07 l=1.3e-07 ng=1
MN11 n13 n10 VSS VSS sg13_lv_nmos w=3e-07 l=1.3e-07 ng=1
MP11 n13 n10 VDD VDD sg13_lv_pmos w=4.5e-07 l=1.3e-07 ng=1
MN12 n10 n0 n14 VSS sg13_lv_nmos w=1.5e-07 l=1.3e-07 ng=1
MN13 n14 n13 VSS VSS sg13_lv_nmos w=1.5e-07 l=1.3e-07 ng=1
MP12 n10 n1 n15 VDD sg13_lv_pmos w=1.5e-07 l=1.3e-07 ng=1
MP13 n15 n13 VDD VDD sg13_lv_pmos w=1.5e-07 l=1.3e-07 ng=1
MN14 Q n13 VSS VSS sg13_lv_nmos w=6.4e-07 l=1.3e-07 ng=1
MP14 Q n13 VDD VDD sg13_lv_pmos w=9.8e-07 l=1.3e-07 ng=1
.ENDS

****************************************
* Cell : DFSQ_D2
* Description : D flip-flop with synchronous set and output Q.
* ┌───────┬─────┬─────┬─────┬───────────────┐
* │ CLK   │ D   │   S │   Q │ Description   │
* ├───────┼─────┼─────┼─────┼───────────────┤
* │ R     │ 0   │   0 │   0 │ Write 0       │
* ├───────┼─────┼─────┼─────┼───────────────┤
* │ R     │ 1   │   0 │   1 │ Write 1       │
* ├───────┼─────┼─────┼─────┼───────────────┤
* │ R     │ -   │   1 │   1 │ Set           │
* └───────┴─────┴─────┴─────┴───────────────┘
****************************************
.SUBCKT DFSQ_D2 D CLK S Q VDD VSS
*.PININFO CLK:I D:I S:I Q:O VDD:B VSS:B
MN0 n0 CLK VSS VSS sg13_lv_nmos w=4e-07 l=1.3e-07 ng=1
MP0 n0 CLK VDD VDD sg13_lv_pmos w=6e-07 l=1.3e-07 ng=1
MN1 n1 n0 VSS VSS sg13_lv_nmos w=3e-07 l=1.3e-07 ng=1
MP1 n1 n0 VDD VDD sg13_lv_pmos w=4.5e-07 l=1.3e-07 ng=1
MN2 n2 S VSS VSS sg13_lv_nmos w=2e-07 l=1.3e-07 ng=1
MN3 n2 D VSS VSS sg13_lv_nmos w=2e-07 l=1.3e-07 ng=1
MP2 n3 S VDD VDD sg13_lv_pmos w=4.5e-07 l=1.3e-07 ng=1
MP3 n2 D n3 VDD sg13_lv_pmos w=4.5e-07 l=1.3e-07 ng=1
MN4 n4 n0 n5 VSS sg13_lv_nmos w=2.5e-07 l=1.3e-07 ng=1
MN5 n5 n2 VSS VSS sg13_lv_nmos w=2.5e-07 l=1.3e-07 ng=1
MP4 n4 n1 n6 VDD sg13_lv_pmos w=3.8e-07 l=1.3e-07 ng=1
MP5 n6 n2 VDD VDD sg13_lv_pmos w=3.8e-07 l=1.3e-07 ng=1
MN6 n7 n4 VSS VSS sg13_lv_nmos w=3e-07 l=1.3e-07 ng=1
MP6 n7 n4 VDD VDD sg13_lv_pmos w=4.5e-07 l=1.3e-07 ng=1
MN7 n4 n1 n8 VSS sg13_lv_nmos w=1.5e-07 l=1.3e-07 ng=1
MN8 n8 n7 VSS VSS sg13_lv_nmos w=1.5e-07 l=1.3e-07 ng=1
MP7 n4 n0 n9 VDD sg13_lv_pmos w=2.3e-07 l=1.3e-07 ng=1
MP8 n9 n7 VDD VDD sg13_lv_pmos w=2.3e-07 l=1.3e-07 ng=1
MN9 n10 n1 n11 VSS sg13_lv_nmos w=9.2e-07 l=1.3e-07 ng=1
MN10 n11 n7 VSS VSS sg13_lv_nmos w=9.2e-07 l=1.3e-07 ng=1
MP9 n10 n0 n12 VDD sg13_lv_pmos w=1.38e-06 l=1.3e-07 ng=1
MP10 n12 n7 VDD VDD sg13_lv_pmos w=1.38e-06 l=1.3e-07 ng=1
MN11 n13 n10 VSS VSS sg13_lv_nmos w=5e-07 l=1.3e-07 ng=1
MP11 n13 n10 VDD VDD sg13_lv_pmos w=7.5e-07 l=1.3e-07 ng=1
MN12 n10 n0 n14 VSS sg13_lv_nmos w=1.5e-07 l=1.3e-07 ng=1
MN13 n14 n13 VSS VSS sg13_lv_nmos w=1.5e-07 l=1.3e-07 ng=1
MP12 n10 n1 n15 VDD sg13_lv_pmos w=1.5e-07 l=1.3e-07 ng=1
MP13 n15 n13 VDD VDD sg13_lv_pmos w=1.5e-07 l=1.3e-07 ng=1
MN14 Q n13 VSS VSS sg13_lv_nmos w=1.07e-06 l=1.3e-07 ng=1
MP14 Q n13 VDD VDD sg13_lv_pmos w=1.6e-06 l=1.3e-07 ng=1
.ENDS

****************************************
* Cell : DFSQ_DL
* Description : D flip-flop with synchronous set and output Q.
* ┌───────┬─────┬─────┬─────┬───────────────┐
* │ CLK   │ D   │   S │   Q │ Description   │
* ├───────┼─────┼─────┼─────┼───────────────┤
* │ R     │ 0   │   0 │   0 │ Write 0       │
* ├───────┼─────┼─────┼─────┼───────────────┤
* │ R     │ 1   │   0 │   1 │ Write 1       │
* ├───────┼─────┼─────┼─────┼───────────────┤
* │ R     │ -   │   1 │   1 │ Set           │
* └───────┴─────┴─────┴─────┴───────────────┘
****************************************
.SUBCKT DFSQ_DL D CLK S Q VDD VSS
*.PININFO CLK:I D:I S:I Q:O VDD:B VSS:B
MN0 n0 CLK VSS VSS sg13_lv_nmos w=2e-07 l=1.3e-07 ng=1
MP0 n0 CLK VDD VDD sg13_lv_pmos w=3e-07 l=1.3e-07 ng=1
MN1 n1 n0 VSS VSS sg13_lv_nmos w=2e-07 l=1.3e-07 ng=1
MP1 n1 n0 VDD VDD sg13_lv_pmos w=3e-07 l=1.3e-07 ng=1
MN2 n2 S VSS VSS sg13_lv_nmos w=1.5e-07 l=1.3e-07 ng=1
MN3 n2 D VSS VSS sg13_lv_nmos w=1.5e-07 l=1.3e-07 ng=1
MP2 n3 S VDD VDD sg13_lv_pmos w=2.3e-07 l=1.3e-07 ng=1
MP3 n2 D n3 VDD sg13_lv_pmos w=2.3e-07 l=1.3e-07 ng=1
MN4 n4 n2 n5 VSS sg13_lv_nmos w=1.5e-07 l=1.3e-07 ng=1
MN5 n5 n0 VSS VSS sg13_lv_nmos w=1.5e-07 l=1.3e-07 ng=1
MP4 n4 n2 n6 VDD sg13_lv_pmos w=2.3e-07 l=1.3e-07 ng=1
MP5 n6 n1 VDD VDD sg13_lv_pmos w=2.3e-07 l=1.3e-07 ng=1
MN6 n7 n4 VSS VSS sg13_lv_nmos w=1.5e-07 l=1.3e-07 ng=1
MP6 n7 n4 VDD VDD sg13_lv_pmos w=2.3e-07 l=1.3e-07 ng=1
MN7 n4 n1 n8 VSS sg13_lv_nmos w=1.5e-07 l=1.3e-07 ng=1
MN8 n8 n7 VSS VSS sg13_lv_nmos w=1.5e-07 l=1.3e-07 ng=1
MP7 n4 n0 n9 VDD sg13_lv_pmos w=2.3e-07 l=1.3e-07 ng=1
MP8 n9 n7 VDD VDD sg13_lv_pmos w=2.3e-07 l=1.3e-07 ng=1
MN9 n10 n1 n11 VSS sg13_lv_nmos w=2e-07 l=1.3e-07 ng=1
MN10 n11 n7 VSS VSS sg13_lv_nmos w=2e-07 l=1.3e-07 ng=1
MP9 n10 n0 n12 VDD sg13_lv_pmos w=3e-07 l=1.3e-07 ng=1
MP10 n12 n7 VDD VDD sg13_lv_pmos w=3e-07 l=1.3e-07 ng=1
MN11 n13 n10 VSS VSS sg13_lv_nmos w=1.5e-07 l=1.3e-07 ng=1
MP11 n13 n10 VDD VDD sg13_lv_pmos w=2.3e-07 l=1.3e-07 ng=1
MN12 n10 n0 n14 VSS sg13_lv_nmos w=1.5e-07 l=1.3e-07 ng=1
MN13 n14 n13 VSS VSS sg13_lv_nmos w=1.5e-07 l=1.3e-07 ng=1
MP12 n10 n1 n15 VDD sg13_lv_pmos w=1.5e-07 l=1.3e-07 ng=1
MP13 n15 n13 VDD VDD sg13_lv_pmos w=1.5e-07 l=1.3e-07 ng=1
MN14 Q n13 VSS VSS sg13_lv_nmos w=3.2e-07 l=1.3e-07 ng=1
MP14 Q n13 VDD VDD sg13_lv_pmos w=4.9e-07 l=1.3e-07 ng=1
.ENDS

****************************************
* Cell : DLN_D1
* Description : D latch with inverted control signal.
* ┌──────┬─────┬─────┬──────┬───────────────┐
* │   GN │ D   │ Q   │ QN   │ Description   │
* ├──────┼─────┼─────┼──────┼───────────────┤
* │    0 │ D   │ D   │ ~D   │ Transparent   │
* ├──────┼─────┼─────┼──────┼───────────────┤
* │    1 │ -   │ Q   │ QN   │ Latch         │
* └──────┴─────┴─────┴──────┴───────────────┘
****************************************
.SUBCKT DLN_D1 D GN Q QN VDD VSS
*.PININFO D:I GN:I Q:O QN:O VDD:B VSS:B
MN0 n0 GN VSS VSS sg13_lv_nmos w=2.5e-07 l=1.3e-07 ng=1
MP0 n0 GN VDD VDD sg13_lv_pmos w=4e-07 l=1.3e-07 ng=1
MN1 n1 n0 VSS VSS sg13_lv_nmos w=1.5e-07 l=1.3e-07 ng=1
MP1 n1 n0 VDD VDD sg13_lv_pmos w=2.3e-07 l=1.3e-07 ng=1
MN2 n2 n1 n3 VSS sg13_lv_nmos w=1.5e-07 l=1.3e-07 ng=1
MN3 n3 n4 VSS VSS sg13_lv_nmos w=1.5e-07 l=1.3e-07 ng=1
MP2 n2 n0 n5 VDD sg13_lv_pmos w=2.3e-07 l=1.3e-07 ng=1
MP3 n5 n4 VDD VDD sg13_lv_pmos w=2.3e-07 l=1.3e-07 ng=1
MN4 n2 n0 n6 VSS sg13_lv_nmos w=5e-07 l=1.3e-07 ng=1
MN5 n6 D VSS VSS sg13_lv_nmos w=5e-07 l=1.3e-07 ng=1
MP4 n2 n1 n7 VDD sg13_lv_pmos w=8e-07 l=1.3e-07 ng=1
MP5 n7 D VDD VDD sg13_lv_pmos w=8e-07 l=1.3e-07 ng=1
MN6 Q n2 VSS VSS sg13_lv_nmos w=6.4e-07 l=1.3e-07 ng=1
MP6 Q n2 VDD VDD sg13_lv_pmos w=9.8e-07 l=1.3e-07 ng=1
MN7 n4 n2 VSS VSS sg13_lv_nmos w=2e-07 l=1.3e-07 ng=1
MP7 n4 n2 VDD VDD sg13_lv_pmos w=3e-07 l=1.3e-07 ng=1
MN8 QN n4 VSS VSS sg13_lv_nmos w=6.4e-07 l=1.3e-07 ng=1
MP8 QN n4 VDD VDD sg13_lv_pmos w=9.8e-07 l=1.3e-07 ng=1
.ENDS

****************************************
* Cell : DLN_D2
* Description : D latch with inverted control signal.
* ┌──────┬─────┬─────┬──────┬───────────────┐
* │   GN │ D   │ Q   │ QN   │ Description   │
* ├──────┼─────┼─────┼──────┼───────────────┤
* │    0 │ D   │ D   │ ~D   │ Transparent   │
* ├──────┼─────┼─────┼──────┼───────────────┤
* │    1 │ -   │ Q   │ QN   │ Latch         │
* └──────┴─────┴─────┴──────┴───────────────┘
****************************************
.SUBCKT DLN_D2 D GN Q QN VDD VSS
*.PININFO D:I GN:I Q:O QN:O VDD:B VSS:B
MN0 n0 GN VSS VSS sg13_lv_nmos w=3e-07 l=1.3e-07 ng=1
MP0 n0 GN VDD VDD sg13_lv_pmos w=5e-07 l=1.3e-07 ng=1
MN1 n1 n0 VSS VSS sg13_lv_nmos w=2.5e-07 l=1.3e-07 ng=1
MP1 n1 n0 VDD VDD sg13_lv_pmos w=4e-07 l=1.3e-07 ng=1
MN2 n2 n1 n3 VSS sg13_lv_nmos w=1.5e-07 l=1.3e-07 ng=1
MN3 n3 n4 VSS VSS sg13_lv_nmos w=1.5e-07 l=1.3e-07 ng=1
MP2 n2 n0 n5 VDD sg13_lv_pmos w=2.3e-07 l=1.3e-07 ng=1
MP3 n5 n4 VDD VDD sg13_lv_pmos w=2.3e-07 l=1.3e-07 ng=1
MN4 n2 n0 n6 VSS sg13_lv_nmos w=8.3e-07 l=1.3e-07 ng=1
MN5 n6 D VSS VSS sg13_lv_nmos w=8.3e-07 l=1.3e-07 ng=1
MP4 n2 n1 n7 VDD sg13_lv_pmos w=1.25e-06 l=1.3e-07 ng=1
MP5 n7 D VDD VDD sg13_lv_pmos w=1.25e-06 l=1.3e-07 ng=1
MN6 Q n2 VSS VSS sg13_lv_nmos w=1.07e-06 l=1.3e-07 ng=1
MP6 Q n2 VDD VDD sg13_lv_pmos w=1.6e-06 l=1.3e-07 ng=1
MN7 n4 n2 VSS VSS sg13_lv_nmos w=3.5e-07 l=1.3e-07 ng=1
MP7 n4 n2 VDD VDD sg13_lv_pmos w=5e-07 l=1.3e-07 ng=1
MN8 QN n4 VSS VSS sg13_lv_nmos w=1.07e-06 l=1.3e-07 ng=1
MP8 QN n4 VDD VDD sg13_lv_pmos w=1.6e-06 l=1.3e-07 ng=1
.ENDS

****************************************
* Cell : DLN_DL
* Description : D latch with inverted control signal.
* ┌──────┬─────┬─────┬──────┬───────────────┐
* │   GN │ D   │ Q   │ QN   │ Description   │
* ├──────┼─────┼─────┼──────┼───────────────┤
* │    0 │ D   │ D   │ ~D   │ Transparent   │
* ├──────┼─────┼─────┼──────┼───────────────┤
* │    1 │ -   │ Q   │ QN   │ Latch         │
* └──────┴─────┴─────┴──────┴───────────────┘
****************************************
.SUBCKT DLN_DL D GN Q QN VDD VSS
*.PININFO D:I GN:I Q:O QN:O VDD:B VSS:B
MN0 n0 GN VSS VSS sg13_lv_nmos w=2e-07 l=1.3e-07 ng=1
MP0 n0 GN VDD VDD sg13_lv_pmos w=3e-07 l=1.3e-07 ng=1
MN1 n1 n0 VSS VSS sg13_lv_nmos w=1.5e-07 l=1.3e-07 ng=1
MP1 n1 n0 VDD VDD sg13_lv_pmos w=2.3e-07 l=1.3e-07 ng=1
MN2 n2 n1 n3 VSS sg13_lv_nmos w=1.5e-07 l=1.3e-07 ng=1
MN3 n3 n4 VSS VSS sg13_lv_nmos w=1.5e-07 l=1.3e-07 ng=1
MP2 n2 n0 n5 VDD sg13_lv_pmos w=2.3e-07 l=1.3e-07 ng=1
MP3 n5 n4 VDD VDD sg13_lv_pmos w=2.3e-07 l=1.3e-07 ng=1
MN4 n2 n0 n6 VSS sg13_lv_nmos w=5e-07 l=1.3e-07 ng=1
MN5 n6 D VSS VSS sg13_lv_nmos w=5e-07 l=1.3e-07 ng=1
MP4 n2 n1 n7 VDD sg13_lv_pmos w=8e-07 l=1.3e-07 ng=1
MP5 n7 D VDD VDD sg13_lv_pmos w=8e-07 l=1.3e-07 ng=1
MN6 Q n2 VSS VSS sg13_lv_nmos w=3.2e-07 l=1.3e-07 ng=1
MP6 Q n2 VDD VDD sg13_lv_pmos w=4.9e-07 l=1.3e-07 ng=1
MN7 n4 n2 VSS VSS sg13_lv_nmos w=2e-07 l=1.3e-07 ng=1
MP7 n4 n2 VDD VDD sg13_lv_pmos w=3e-07 l=1.3e-07 ng=1
MN8 QN n4 VSS VSS sg13_lv_nmos w=3.2e-07 l=1.3e-07 ng=1
MP8 QN n4 VDD VDD sg13_lv_pmos w=4.9e-07 l=1.3e-07 ng=1
.ENDS

****************************************
* Cell : DL_D1
* Description : D latch.
* ┌─────┬─────┬─────┬──────┬───────────────┐
* │   G │ D   │ Q   │ QN   │ Description   │
* ├─────┼─────┼─────┼──────┼───────────────┤
* │   1 │ D   │ D   │ ~D   │ Transparent   │
* ├─────┼─────┼─────┼──────┼───────────────┤
* │   0 │ -   │ Q   │ QN   │ Latch         │
* └─────┴─────┴─────┴──────┴───────────────┘
****************************************
.SUBCKT DL_D1 D G Q QN VDD VSS
*.PININFO D:I G:I Q:O QN:O VDD:B VSS:B
MN0 n0 G VSS VSS sg13_lv_nmos w=2.5e-07 l=1.3e-07 ng=1
MP0 n0 G VDD VDD sg13_lv_pmos w=4e-07 l=1.3e-07 ng=1
MN1 n1 n0 VSS VSS sg13_lv_nmos w=1.6e-07 l=1.3e-07 ng=1
MP1 n1 n0 VDD VDD sg13_lv_pmos w=2.3e-07 l=1.3e-07 ng=1
MN2 n2 n0 n3 VSS sg13_lv_nmos w=1.5e-07 l=1.3e-07 ng=1
MN3 n3 n4 VSS VSS sg13_lv_nmos w=1.5e-07 l=1.3e-07 ng=1
MP2 n2 n1 n5 VDD sg13_lv_pmos w=2.3e-07 l=1.3e-07 ng=1
MP3 n5 n4 VDD VDD sg13_lv_pmos w=2.3e-07 l=1.3e-07 ng=1
MN4 n2 n1 n6 VSS sg13_lv_nmos w=4.4e-07 l=1.3e-07 ng=1
MN5 n6 D VSS VSS sg13_lv_nmos w=4.4e-07 l=1.3e-07 ng=1
MP4 n2 n0 n7 VDD sg13_lv_pmos w=7.5e-07 l=1.3e-07 ng=1
MP5 n7 D VDD VDD sg13_lv_pmos w=7.5e-07 l=1.3e-07 ng=1
MN6 Q n2 VSS VSS sg13_lv_nmos w=6.4e-07 l=1.3e-07 ng=1
MP6 Q n2 VDD VDD sg13_lv_pmos w=9.8e-07 l=1.3e-07 ng=1
MN7 n4 n2 VSS VSS sg13_lv_nmos w=1.5e-07 l=1.3e-07 ng=1
MP7 n4 n2 VDD VDD sg13_lv_pmos w=2.3e-07 l=1.3e-07 ng=1
MN8 QN n4 VSS VSS sg13_lv_nmos w=6.4e-07 l=1.3e-07 ng=1
MP8 QN n4 VDD VDD sg13_lv_pmos w=9.8e-07 l=1.3e-07 ng=1
.ENDS

****************************************
* Cell : DL_D2
* Description : D latch.
* ┌─────┬─────┬─────┬──────┬───────────────┐
* │   G │ D   │ Q   │ QN   │ Description   │
* ├─────┼─────┼─────┼──────┼───────────────┤
* │   1 │ D   │ D   │ ~D   │ Transparent   │
* ├─────┼─────┼─────┼──────┼───────────────┤
* │   0 │ -   │ Q   │ QN   │ Latch         │
* └─────┴─────┴─────┴──────┴───────────────┘
****************************************
.SUBCKT DL_D2 D G Q QN VDD VSS
*.PININFO D:I G:I Q:O QN:O VDD:B VSS:B
MN0 n0 G VSS VSS sg13_lv_nmos w=3e-07 l=1.3e-07 ng=1
MP0 n0 G VDD VDD sg13_lv_pmos w=5e-07 l=1.3e-07 ng=1
MN1 n1 n0 VSS VSS sg13_lv_nmos w=2.5e-07 l=1.3e-07 ng=1
MP1 n1 n0 VDD VDD sg13_lv_pmos w=4e-07 l=1.3e-07 ng=1
MN2 n2 n0 n3 VSS sg13_lv_nmos w=1.5e-07 l=1.3e-07 ng=1
MN3 n3 n4 VSS VSS sg13_lv_nmos w=1.5e-07 l=1.3e-07 ng=1
MP2 n2 n1 n5 VDD sg13_lv_pmos w=2.3e-07 l=1.3e-07 ng=1
MP3 n5 n4 VDD VDD sg13_lv_pmos w=2.3e-07 l=1.3e-07 ng=1
MN4 n2 n1 n6 VSS sg13_lv_nmos w=1e-06 l=1.3e-07 ng=1
MN5 n6 D VSS VSS sg13_lv_nmos w=1e-06 l=1.3e-07 ng=1
MP4 n2 n0 n7 VDD sg13_lv_pmos w=1.3e-06 l=1.3e-07 ng=1
MP5 n7 D VDD VDD sg13_lv_pmos w=1.3e-06 l=1.3e-07 ng=1
MN6 Q n2 VSS VSS sg13_lv_nmos w=1.07e-06 l=1.3e-07 ng=1
MP6 Q n2 VDD VDD sg13_lv_pmos w=1.6e-06 l=1.3e-07 ng=1
MN7 n4 n2 VSS VSS sg13_lv_nmos w=3.5e-07 l=1.3e-07 ng=1
MP7 n4 n2 VDD VDD sg13_lv_pmos w=5e-07 l=1.3e-07 ng=1
MN8 QN n4 VSS VSS sg13_lv_nmos w=1.07e-06 l=1.3e-07 ng=1
MP8 QN n4 VDD VDD sg13_lv_pmos w=1.6e-06 l=1.3e-07 ng=1
.ENDS

****************************************
* Cell : DL_DL
* Description : D latch.
* ┌─────┬─────┬─────┬──────┬───────────────┐
* │   G │ D   │ Q   │ QN   │ Description   │
* ├─────┼─────┼─────┼──────┼───────────────┤
* │   1 │ D   │ D   │ ~D   │ Transparent   │
* ├─────┼─────┼─────┼──────┼───────────────┤
* │   0 │ -   │ Q   │ QN   │ Latch         │
* └─────┴─────┴─────┴──────┴───────────────┘
****************************************
.SUBCKT DL_DL D G Q QN VDD VSS
*.PININFO D:I G:I Q:O QN:O VDD:B VSS:B
MN0 n0 G VSS VSS sg13_lv_nmos w=2e-07 l=1.3e-07 ng=1
MP0 n0 G VDD VDD sg13_lv_pmos w=3e-07 l=1.3e-07 ng=1
MN1 n1 n0 VSS VSS sg13_lv_nmos w=1.6e-07 l=1.3e-07 ng=1
MP1 n1 n0 VDD VDD sg13_lv_pmos w=2.3e-07 l=1.3e-07 ng=1
MN2 n2 n3 n4 VSS sg13_lv_nmos w=1.5e-07 l=1.3e-07 ng=1
MN3 n4 n0 VSS VSS sg13_lv_nmos w=1.5e-07 l=1.3e-07 ng=1
MP2 n2 n3 n5 VDD sg13_lv_pmos w=2.3e-07 l=1.3e-07 ng=1
MP3 n5 n1 VDD VDD sg13_lv_pmos w=2.3e-07 l=1.3e-07 ng=1
MN4 n2 D n6 VSS sg13_lv_nmos w=3e-07 l=1.3e-07 ng=1
MN5 n6 n1 VSS VSS sg13_lv_nmos w=3e-07 l=1.3e-07 ng=1
MP4 n2 D n7 VDD sg13_lv_pmos w=4.5e-07 l=1.3e-07 ng=1
MP5 n7 n0 VDD VDD sg13_lv_pmos w=4.5e-07 l=1.3e-07 ng=1
MN6 Q n2 VSS VSS sg13_lv_nmos w=3.2e-07 l=1.3e-07 ng=1
MP6 Q n2 VDD VDD sg13_lv_pmos w=4.9e-07 l=1.3e-07 ng=1
MN7 n3 n2 VSS VSS sg13_lv_nmos w=1.5e-07 l=1.3e-07 ng=1
MP7 n3 n2 VDD VDD sg13_lv_pmos w=2.3e-07 l=1.3e-07 ng=1
MN8 QN n3 VSS VSS sg13_lv_nmos w=3.2e-07 l=1.3e-07 ng=1
MP8 QN n3 VDD VDD sg13_lv_pmos w=4.9e-07 l=1.3e-07 ng=1
.ENDS

****************************************
* Cell : INV_D1
* Description : Standard inverter
* Reduced truth table for output Y
* ┌─────┬─────┐
* │   A │   Y │
* ├─────┼─────┤
* │   0 │   1 │
* ├─────┼─────┤
* │   1 │   0 │
* └─────┴─────┘
****************************************
.SUBCKT INV_D1 A Y VDD VSS
*.PININFO A:I Y:O VDD:B VSS:B
MN0 Y A VSS VSS sg13_lv_nmos w=6.4e-07 l=1.3e-07 ng=1
MP0 Y A VDD VDD sg13_lv_pmos w=9.8e-07 l=1.3e-07 ng=1
.ENDS

****************************************
* Cell : INV_D12
* Description : Standard inverter
* Reduced truth table for output Y
* ┌─────┬─────┐
* │   A │   Y │
* ├─────┼─────┤
* │   0 │   1 │
* ├─────┼─────┤
* │   1 │   0 │
* └─────┴─────┘
****************************************
.SUBCKT INV_D12 A Y VDD VSS
*.PININFO A:I Y:O VDD:B VSS:B
MN0 Y A VSS VSS sg13_lv_nmos w=6.42e-06 l=1.3e-07 ng=6
MP0 Y A VDD VDD sg13_lv_pmos w=9.6e-06 l=1.3e-07 ng=6
.ENDS

****************************************
* Cell : INV_D14
* Description : Standard inverter
* Reduced truth table for output Y
* ┌─────┬─────┐
* │   A │   Y │
* ├─────┼─────┤
* │   0 │   1 │
* ├─────┼─────┤
* │   1 │   0 │
* └─────┴─────┘
****************************************
.SUBCKT INV_D14 A Y VDD VSS
*.PININFO A:I Y:O VDD:B VSS:B
MN0 Y A VSS VSS sg13_lv_nmos w=7.49e-06 l=1.3e-07 ng=7
MP0 Y A VDD VDD sg13_lv_pmos w=1.12e-05 l=1.3e-07 ng=7
.ENDS

****************************************
* Cell : INV_D16
* Description : Standard inverter
* Reduced truth table for output Y
* ┌─────┬─────┐
* │   A │   Y │
* ├─────┼─────┤
* │   0 │   1 │
* ├─────┼─────┤
* │   1 │   0 │
* └─────┴─────┘
****************************************
.SUBCKT INV_D16 A Y VDD VSS
*.PININFO A:I Y:O VDD:B VSS:B
MN0 Y A VSS VSS sg13_lv_nmos w=8.56e-06 l=1.3e-07 ng=8
MP0 Y A VDD VDD sg13_lv_pmos w=1.28e-05 l=1.3e-07 ng=8
.ENDS

****************************************
* Cell : INV_D2
* Description : Standard inverter
* Reduced truth table for output Y
* ┌─────┬─────┐
* │   A │   Y │
* ├─────┼─────┤
* │   0 │   1 │
* ├─────┼─────┤
* │   1 │   0 │
* └─────┴─────┘
****************************************
.SUBCKT INV_D2 A Y VDD VSS
*.PININFO A:I Y:O VDD:B VSS:B
MN0 Y A VSS VSS sg13_lv_nmos w=1.07e-06 l=1.3e-07 ng=1
MP0 Y A VDD VDD sg13_lv_pmos w=1.6e-06 l=1.3e-07 ng=1
.ENDS

****************************************
* Cell : INV_D4
* Description : Standard inverter
* Reduced truth table for output Y
* ┌─────┬─────┐
* │   A │   Y │
* ├─────┼─────┤
* │   0 │   1 │
* ├─────┼─────┤
* │   1 │   0 │
* └─────┴─────┘
****************************************
.SUBCKT INV_D4 A Y VDD VSS
*.PININFO A:I Y:O VDD:B VSS:B
MN0 Y A VSS VSS sg13_lv_nmos w=2.14e-06 l=1.3e-07 ng=2
MP0 Y A VDD VDD sg13_lv_pmos w=3.2e-06 l=1.3e-07 ng=2
.ENDS

****************************************
* Cell : INV_D8
* Description : Standard inverter
* Reduced truth table for output Y
* ┌─────┬─────┐
* │   A │   Y │
* ├─────┼─────┤
* │   0 │   1 │
* ├─────┼─────┤
* │   1 │   0 │
* └─────┴─────┘
****************************************
.SUBCKT INV_D8 A Y VDD VSS
*.PININFO A:I Y:O VDD:B VSS:B
MN0 Y A VSS VSS sg13_lv_nmos w=4.28e-06 l=1.3e-07 ng=4
MP0 Y A VDD VDD sg13_lv_pmos w=6.4e-06 l=1.3e-07 ng=4
.ENDS

****************************************
* Cell : INV_DL
* Description : Standard inverter
* Reduced truth table for output Y
* ┌─────┬─────┐
* │   A │   Y │
* ├─────┼─────┤
* │   0 │   1 │
* ├─────┼─────┤
* │   1 │   0 │
* └─────┴─────┘
****************************************
.SUBCKT INV_DL A Y VDD VSS
*.PININFO A:I Y:O VDD:B VSS:B
MN0 Y A VSS VSS sg13_lv_nmos w=3.2e-07 l=1.3e-07 ng=1
MP0 Y A VDD VDD sg13_lv_pmos w=6.6e-07 l=1.3e-07 ng=1
.ENDS

****************************************
* Cell : MUX2N_D1
* Description : Two input multiplexer with inverted output.
* Reduced truth table for output YN
* ┌──────┬──────┬──────┬──────┐
* │ I0   │ I1   │   S0 │   YN │
* ├──────┼──────┼──────┼──────┤
* │ -    │ 0    │    1 │    1 │
* ├──────┼──────┼──────┼──────┤
* │ 0    │ -    │    0 │    1 │
* ├──────┼──────┼──────┼──────┤
* │ 1    │ -    │    0 │    0 │
* ├──────┼──────┼──────┼──────┤
* │ -    │ 1    │    1 │    0 │
* └──────┴──────┴──────┴──────┘
****************************************
.SUBCKT MUX2N_D1 I0 I1 S0 YN VDD VSS
*.PININFO I0:I I1:I S0:I YN:O VDD:B VSS:B
MN0 n0 S0 VSS VSS sg13_lv_nmos w=2.4e-07 l=1.3e-07 ng=1
MP0 n0 S0 VDD VDD sg13_lv_pmos w=3.6e-07 l=1.3e-07 ng=1
MN1 YN n0 n1 VSS sg13_lv_nmos w=6.4e-07 l=1.3e-07 ng=1
MN2 n1 I0 VSS VSS sg13_lv_nmos w=6.4e-07 l=1.3e-07 ng=1
MP1 YN S0 n2 VDD sg13_lv_pmos w=9.6e-07 l=1.3e-07 ng=1
MP2 n2 I0 VDD VDD sg13_lv_pmos w=9.6e-07 l=1.3e-07 ng=1
MN3 YN S0 n3 VSS sg13_lv_nmos w=6.4e-07 l=1.3e-07 ng=1
MN4 n3 I1 VSS VSS sg13_lv_nmos w=6.4e-07 l=1.3e-07 ng=1
MP3 YN n0 n4 VDD sg13_lv_pmos w=9.6e-07 l=1.3e-07 ng=1
MP4 n4 I1 VDD VDD sg13_lv_pmos w=9.6e-07 l=1.3e-07 ng=1
.ENDS

****************************************
* Cell : MUX2N_DL
* Description : Two input multiplexer with inverted output.
* Reduced truth table for output YN
* ┌──────┬──────┬──────┬──────┐
* │ I0   │ I1   │   S0 │   YN │
* ├──────┼──────┼──────┼──────┤
* │ -    │ 0    │    1 │    1 │
* ├──────┼──────┼──────┼──────┤
* │ 0    │ -    │    0 │    1 │
* ├──────┼──────┼──────┼──────┤
* │ 1    │ -    │    0 │    0 │
* ├──────┼──────┼──────┼──────┤
* │ -    │ 1    │    1 │    0 │
* └──────┴──────┴──────┴──────┘
****************************************
.SUBCKT MUX2N_DL I0 I1 S0 YN VDD VSS
*.PININFO I0:I I1:I S0:I YN:O VDD:B VSS:B
MN0 n0 S0 VSS VSS sg13_lv_nmos w=1.5e-07 l=1.3e-07 ng=1
MP0 n0 S0 VDD VDD sg13_lv_pmos w=2.3e-07 l=1.3e-07 ng=1
MN1 YN n0 n1 VSS sg13_lv_nmos w=3.2e-07 l=1.3e-07 ng=1
MN2 n1 I0 VSS VSS sg13_lv_nmos w=3.2e-07 l=1.3e-07 ng=1
MP1 YN S0 n2 VDD sg13_lv_pmos w=4.8e-07 l=1.3e-07 ng=1
MP2 n2 I0 VDD VDD sg13_lv_pmos w=4.8e-07 l=1.3e-07 ng=1
MN3 YN S0 n3 VSS sg13_lv_nmos w=3.2e-07 l=1.3e-07 ng=1
MN4 n3 I1 VSS VSS sg13_lv_nmos w=3.2e-07 l=1.3e-07 ng=1
MP3 YN n0 n4 VDD sg13_lv_pmos w=4.8e-07 l=1.3e-07 ng=1
MP4 n4 I1 VDD VDD sg13_lv_pmos w=4.8e-07 l=1.3e-07 ng=1
.ENDS

****************************************
* Cell : MUX2_D1
* Description : Two input multiplexer.
* Reduced truth table for output Y
* ┌──────┬──────┬──────┬─────┐
* │ I0   │ I1   │   S0 │   Y │
* ├──────┼──────┼──────┼─────┤
* │ -    │ 1    │    1 │   1 │
* ├──────┼──────┼──────┼─────┤
* │ 1    │ -    │    0 │   1 │
* ├──────┼──────┼──────┼─────┤
* │ 0    │ -    │    0 │   0 │
* ├──────┼──────┼──────┼─────┤
* │ -    │ 0    │    1 │   0 │
* └──────┴──────┴──────┴─────┘
****************************************
.SUBCKT MUX2_D1 I0 I1 S0 Y VDD VSS
*.PININFO I0:I I1:I S0:I Y:O VDD:B VSS:B
MN0 n0 S0 VSS VSS sg13_lv_nmos w=1.5e-07 l=1.3e-07 ng=1
MP0 n0 S0 VDD VDD sg13_lv_pmos w=2.3e-07 l=1.3e-07 ng=1
MN1 Y n1 VSS VSS sg13_lv_nmos w=6.4e-07 l=1.3e-07 ng=1
MP1 Y n1 VDD VDD sg13_lv_pmos w=9.8e-07 l=1.3e-07 ng=1
MN2 n1 n0 n2 VSS sg13_lv_nmos w=4e-07 l=1.3e-07 ng=1
MN3 n2 I0 VSS VSS sg13_lv_nmos w=4e-07 l=1.3e-07 ng=1
MP2 n1 S0 n3 VDD sg13_lv_pmos w=6e-07 l=1.3e-07 ng=1
MP3 n3 I0 VDD VDD sg13_lv_pmos w=6e-07 l=1.3e-07 ng=1
MN4 n1 S0 n4 VSS sg13_lv_nmos w=4e-07 l=1.3e-07 ng=1
MN5 n4 I1 VSS VSS sg13_lv_nmos w=4e-07 l=1.3e-07 ng=1
MP4 n1 n0 n5 VDD sg13_lv_pmos w=6e-07 l=1.3e-07 ng=1
MP5 n5 I1 VDD VDD sg13_lv_pmos w=6e-07 l=1.3e-07 ng=1
.ENDS

****************************************
* Cell : MUX2_DL
* Description : Two input multiplexer.
* Reduced truth table for output Y
* ┌──────┬──────┬──────┬─────┐
* │ I0   │ I1   │   S0 │   Y │
* ├──────┼──────┼──────┼─────┤
* │ -    │ 1    │    1 │   1 │
* ├──────┼──────┼──────┼─────┤
* │ 1    │ -    │    0 │   1 │
* ├──────┼──────┼──────┼─────┤
* │ 0    │ -    │    0 │   0 │
* ├──────┼──────┼──────┼─────┤
* │ -    │ 0    │    1 │   0 │
* └──────┴──────┴──────┴─────┘
****************************************
.SUBCKT MUX2_DL I0 I1 S0 Y VDD VSS
*.PININFO I0:I I1:I S0:I Y:O VDD:B VSS:B
MN0 n0 S0 VSS VSS sg13_lv_nmos w=2e-07 l=1.3e-07 ng=1
MP0 n0 S0 VDD VDD sg13_lv_pmos w=3e-07 l=1.3e-07 ng=1
MN1 Y n1 VSS VSS sg13_lv_nmos w=3.2e-07 l=1.3e-07 ng=1
MP1 Y n1 VDD VDD sg13_lv_pmos w=4.9e-07 l=1.3e-07 ng=1
MN2 n1 n0 n2 VSS sg13_lv_nmos w=2e-07 l=1.3e-07 ng=1
MN3 n2 I0 VSS VSS sg13_lv_nmos w=2e-07 l=1.3e-07 ng=1
MP2 n1 S0 n3 VDD sg13_lv_pmos w=3e-07 l=1.3e-07 ng=1
MP3 n3 I0 VDD VDD sg13_lv_pmos w=3e-07 l=1.3e-07 ng=1
MN4 n1 S0 n4 VSS sg13_lv_nmos w=2e-07 l=1.3e-07 ng=1
MN5 n4 I1 VSS VSS sg13_lv_nmos w=2e-07 l=1.3e-07 ng=1
MP4 n1 n0 n5 VDD sg13_lv_pmos w=3e-07 l=1.3e-07 ng=1
MP5 n5 I1 VDD VDD sg13_lv_pmos w=3e-07 l=1.3e-07 ng=1
.ENDS

****************************************
* Cell : MUX3_D1
* Description : Three input multiplexer.
* Reduced truth table for output Y
* ┌──────┬──────┬──────┬──────┬──────┬─────┐
* │ I0   │ I1   │ I2   │ S0   │   S1 │   Y │
* ├──────┼──────┼──────┼──────┼──────┼─────┤
* │ -    │ -    │ 1    │ -    │    1 │   1 │
* ├──────┼──────┼──────┼──────┼──────┼─────┤
* │ -    │ 1    │ -    │ 1    │    0 │   1 │
* ├──────┼──────┼──────┼──────┼──────┼─────┤
* │ 1    │ -    │ -    │ 0    │    0 │   1 │
* ├──────┼──────┼──────┼──────┼──────┼─────┤
* │ -    │ -    │ 0    │ -    │    1 │   0 │
* ├──────┼──────┼──────┼──────┼──────┼─────┤
* │ 0    │ -    │ -    │ 0    │    0 │   0 │
* ├──────┼──────┼──────┼──────┼──────┼─────┤
* │ -    │ 0    │ -    │ 1    │    0 │   0 │
* └──────┴──────┴──────┴──────┴──────┴─────┘
****************************************
.SUBCKT MUX3_D1 I0 I1 I2 S0 S1 Y VDD VSS
*.PININFO I0:I I1:I I2:I S0:I S1:I Y:O VDD:B VSS:B
MN0 n0 S0 VSS VSS sg13_lv_nmos w=2.5e-07 l=1.3e-07 ng=1
MP0 n0 S0 VDD VDD sg13_lv_pmos w=4e-07 l=1.3e-07 ng=1
MN1 n1 S1 VSS VSS sg13_lv_nmos w=1.5e-07 l=1.3e-07 ng=1
MP1 n1 S1 VDD VDD sg13_lv_pmos w=2.3e-07 l=1.3e-07 ng=1
MN2 Y n2 VSS VSS sg13_lv_nmos w=6.4e-07 l=1.3e-07 ng=1
MP2 Y n2 VDD VDD sg13_lv_pmos w=9.8e-07 l=1.3e-07 ng=1
MN3 n3 n0 n4 VSS sg13_lv_nmos w=6e-07 l=1.3e-07 ng=1
MN4 n4 I0 VSS VSS sg13_lv_nmos w=6e-07 l=1.3e-07 ng=1
MP3 n3 S0 n5 VDD sg13_lv_pmos w=9e-07 l=1.3e-07 ng=1
MP4 n5 I0 VDD VDD sg13_lv_pmos w=9e-07 l=1.3e-07 ng=1
MN5 n3 S0 n6 VSS sg13_lv_nmos w=6e-07 l=1.3e-07 ng=1
MN6 n6 I1 VSS VSS sg13_lv_nmos w=6e-07 l=1.3e-07 ng=1
MP5 n3 n0 n7 VDD sg13_lv_pmos w=9e-07 l=1.3e-07 ng=1
MP6 n7 I1 VDD VDD sg13_lv_pmos w=9e-07 l=1.3e-07 ng=1
MN7 n2 S1 n8 VSS sg13_lv_nmos w=4.3e-07 l=1.3e-07 ng=1
MN8 n8 I2 VSS VSS sg13_lv_nmos w=4.3e-07 l=1.3e-07 ng=1
MP7 n2 n1 n9 VDD sg13_lv_pmos w=6e-07 l=1.3e-07 ng=1
MP8 n9 I2 VDD VDD sg13_lv_pmos w=6e-07 l=1.3e-07 ng=1
MN9 n3 n1 n2 VSS sg13_lv_nmos w=6e-07 l=1.3e-07 ng=1
MP9 n3 S1 n2 VDD sg13_lv_pmos w=9e-07 l=1.3e-07 ng=1
.ENDS

****************************************
* Cell : MUX3_DL
* Description : Three input multiplexer.
* Reduced truth table for output Y
* ┌──────┬──────┬──────┬──────┬──────┬─────┐
* │ I0   │ I1   │ I2   │ S0   │   S1 │   Y │
* ├──────┼──────┼──────┼──────┼──────┼─────┤
* │ -    │ -    │ 1    │ -    │    1 │   1 │
* ├──────┼──────┼──────┼──────┼──────┼─────┤
* │ -    │ 1    │ -    │ 1    │    0 │   1 │
* ├──────┼──────┼──────┼──────┼──────┼─────┤
* │ 1    │ -    │ -    │ 0    │    0 │   1 │
* ├──────┼──────┼──────┼──────┼──────┼─────┤
* │ -    │ -    │ 0    │ -    │    1 │   0 │
* ├──────┼──────┼──────┼──────┼──────┼─────┤
* │ 0    │ -    │ -    │ 0    │    0 │   0 │
* ├──────┼──────┼──────┼──────┼──────┼─────┤
* │ -    │ 0    │ -    │ 1    │    0 │   0 │
* └──────┴──────┴──────┴──────┴──────┴─────┘
****************************************
.SUBCKT MUX3_DL I0 I1 I2 S0 S1 Y VDD VSS
*.PININFO I0:I I1:I I2:I S0:I S1:I Y:O VDD:B VSS:B
MN0 n0 S0 VSS VSS sg13_lv_nmos w=1.5e-07 l=1.3e-07 ng=1
MP0 n0 S0 VDD VDD sg13_lv_pmos w=2.3e-07 l=1.3e-07 ng=1
MN1 n1 S1 VSS VSS sg13_lv_nmos w=1.5e-07 l=1.3e-07 ng=1
MP1 n1 S1 VDD VDD sg13_lv_pmos w=2.3e-07 l=1.3e-07 ng=1
MN2 Y n2 VSS VSS sg13_lv_nmos w=3.2e-07 l=1.3e-07 ng=1
MP2 Y n2 VDD VDD sg13_lv_pmos w=4.9e-07 l=1.3e-07 ng=1
MN3 n3 n0 n4 VSS sg13_lv_nmos w=3e-07 l=1.3e-07 ng=1
MN4 n4 I0 VSS VSS sg13_lv_nmos w=3e-07 l=1.3e-07 ng=1
MP3 n3 S0 n5 VDD sg13_lv_pmos w=4.5e-07 l=1.3e-07 ng=1
MP4 n5 I0 VDD VDD sg13_lv_pmos w=4.5e-07 l=1.3e-07 ng=1
MN5 n3 S0 n6 VSS sg13_lv_nmos w=3e-07 l=1.3e-07 ng=1
MN6 n6 I1 VSS VSS sg13_lv_nmos w=3e-07 l=1.3e-07 ng=1
MP5 n3 n0 n7 VDD sg13_lv_pmos w=4.5e-07 l=1.3e-07 ng=1
MP6 n7 I1 VDD VDD sg13_lv_pmos w=4.5e-07 l=1.3e-07 ng=1
MN7 n2 S1 n8 VSS sg13_lv_nmos w=2.3e-07 l=1.3e-07 ng=1
MN8 n8 I2 VSS VSS sg13_lv_nmos w=2.3e-07 l=1.3e-07 ng=1
MP7 n2 n1 n9 VDD sg13_lv_pmos w=3e-07 l=1.3e-07 ng=1
MP8 n9 I2 VDD VDD sg13_lv_pmos w=3e-07 l=1.3e-07 ng=1
MN9 n3 n1 n2 VSS sg13_lv_nmos w=3e-07 l=1.3e-07 ng=1
MP9 n3 S1 n2 VDD sg13_lv_pmos w=4.5e-07 l=1.3e-07 ng=1
.ENDS

****************************************
* Cell : MUX4_D1
* Description : Four input multiplexer.
* Reduced truth table for output Y
* ┌──────┬──────┬──────┬──────┬──────┬──────┬─────┐
* │ I0   │ I1   │ I2   │ I3   │   S0 │   S1 │   Y │
* ├──────┼──────┼──────┼──────┼──────┼──────┼─────┤
* │ -    │ -    │ -    │ 1    │    1 │    1 │   1 │
* ├──────┼──────┼──────┼──────┼──────┼──────┼─────┤
* │ -    │ 1    │ -    │ -    │    1 │    0 │   1 │
* ├──────┼──────┼──────┼──────┼──────┼──────┼─────┤
* │ -    │ -    │ 1    │ -    │    0 │    1 │   1 │
* ├──────┼──────┼──────┼──────┼──────┼──────┼─────┤
* │ 1    │ -    │ -    │ -    │    0 │    0 │   1 │
* ├──────┼──────┼──────┼──────┼──────┼──────┼─────┤
* │ 0    │ -    │ -    │ -    │    0 │    0 │   0 │
* ├──────┼──────┼──────┼──────┼──────┼──────┼─────┤
* │ -    │ 0    │ -    │ -    │    1 │    0 │   0 │
* ├──────┼──────┼──────┼──────┼──────┼──────┼─────┤
* │ -    │ -    │ 0    │ -    │    0 │    1 │   0 │
* ├──────┼──────┼──────┼──────┼──────┼──────┼─────┤
* │ -    │ -    │ -    │ 0    │    1 │    1 │   0 │
* └──────┴──────┴──────┴──────┴──────┴──────┴─────┘
****************************************
.SUBCKT MUX4_D1 I0 I1 I2 I3 S0 S1 Y VDD VSS
*.PININFO I0:I I1:I I2:I I3:I S0:I S1:I Y:O VDD:B VSS:B
MN0 n0 S0 VSS VSS sg13_lv_nmos w=5e-07 l=1.3e-07 ng=1
MP0 n0 S0 VDD VDD sg13_lv_pmos w=7.5e-07 l=1.3e-07 ng=1
MN1 n1 S1 VSS VSS sg13_lv_nmos w=3e-07 l=1.3e-07 ng=1
MP1 n1 S1 VDD VDD sg13_lv_pmos w=4.5e-07 l=1.3e-07 ng=1
MN2 Y n2 VSS VSS sg13_lv_nmos w=6.4e-07 l=1.3e-07 ng=1
MP2 Y n2 VDD VDD sg13_lv_pmos w=9.8e-07 l=1.3e-07 ng=1
MN3 n3 n0 n4 VSS sg13_lv_nmos w=6e-07 l=1.3e-07 ng=1
MN4 n4 I0 VSS VSS sg13_lv_nmos w=6e-07 l=1.3e-07 ng=1
MP3 n3 S0 n5 VDD sg13_lv_pmos w=9e-07 l=1.3e-07 ng=1
MP4 n5 I0 VDD VDD sg13_lv_pmos w=9e-07 l=1.3e-07 ng=1
MN5 n3 S0 n6 VSS sg13_lv_nmos w=6e-07 l=1.3e-07 ng=1
MN6 n6 I1 VSS VSS sg13_lv_nmos w=6e-07 l=1.3e-07 ng=1
MP5 n3 n0 n7 VDD sg13_lv_pmos w=9e-07 l=1.3e-07 ng=1
MP6 n7 I1 VDD VDD sg13_lv_pmos w=9e-07 l=1.3e-07 ng=1
MN7 n8 n0 n9 VSS sg13_lv_nmos w=6e-07 l=1.3e-07 ng=1
MN8 n9 I2 VSS VSS sg13_lv_nmos w=6e-07 l=1.3e-07 ng=1
MP7 n8 S0 n10 VDD sg13_lv_pmos w=9e-07 l=1.3e-07 ng=1
MP8 n10 I2 VDD VDD sg13_lv_pmos w=9e-07 l=1.3e-07 ng=1
MN9 n8 S0 n11 VSS sg13_lv_nmos w=6e-07 l=1.3e-07 ng=1
MN10 n11 I3 VSS VSS sg13_lv_nmos w=6e-07 l=1.3e-07 ng=1
MP9 n8 n0 n12 VDD sg13_lv_pmos w=9e-07 l=1.3e-07 ng=1
MP10 n12 I3 VDD VDD sg13_lv_pmos w=9e-07 l=1.3e-07 ng=1
MN11 n3 n1 n2 VSS sg13_lv_nmos w=6e-07 l=1.3e-07 ng=1
MP11 n3 S1 n2 VDD sg13_lv_pmos w=9e-07 l=1.3e-07 ng=1
MN12 n8 S1 n2 VSS sg13_lv_nmos w=6e-07 l=1.3e-07 ng=1
MP12 n8 n1 n2 VDD sg13_lv_pmos w=9e-07 l=1.3e-07 ng=1
.ENDS

****************************************
* Cell : MUX4_DL
* Description : Four input multiplexer.
* Reduced truth table for output Y
* ┌──────┬──────┬──────┬──────┬──────┬──────┬─────┐
* │ I0   │ I1   │ I2   │ I3   │   S0 │   S1 │   Y │
* ├──────┼──────┼──────┼──────┼──────┼──────┼─────┤
* │ -    │ -    │ -    │ 1    │    1 │    1 │   1 │
* ├──────┼──────┼──────┼──────┼──────┼──────┼─────┤
* │ -    │ 1    │ -    │ -    │    1 │    0 │   1 │
* ├──────┼──────┼──────┼──────┼──────┼──────┼─────┤
* │ -    │ -    │ 1    │ -    │    0 │    1 │   1 │
* ├──────┼──────┼──────┼──────┼──────┼──────┼─────┤
* │ 1    │ -    │ -    │ -    │    0 │    0 │   1 │
* ├──────┼──────┼──────┼──────┼──────┼──────┼─────┤
* │ 0    │ -    │ -    │ -    │    0 │    0 │   0 │
* ├──────┼──────┼──────┼──────┼──────┼──────┼─────┤
* │ -    │ 0    │ -    │ -    │    1 │    0 │   0 │
* ├──────┼──────┼──────┼──────┼──────┼──────┼─────┤
* │ -    │ -    │ 0    │ -    │    0 │    1 │   0 │
* ├──────┼──────┼──────┼──────┼──────┼──────┼─────┤
* │ -    │ -    │ -    │ 0    │    1 │    1 │   0 │
* └──────┴──────┴──────┴──────┴──────┴──────┴─────┘
****************************************
.SUBCKT MUX4_DL I0 I1 I2 I3 S0 S1 Y VDD VSS
*.PININFO I0:I I1:I I2:I I3:I S0:I S1:I Y:O VDD:B VSS:B
MN0 n0 S0 VSS VSS sg13_lv_nmos w=2e-07 l=1.3e-07 ng=1
MP0 n0 S0 VDD VDD sg13_lv_pmos w=3e-07 l=1.3e-07 ng=1
MN1 n1 S1 VSS VSS sg13_lv_nmos w=2e-07 l=1.3e-07 ng=1
MP1 n1 S1 VDD VDD sg13_lv_pmos w=3e-07 l=1.3e-07 ng=1
MN2 Y n2 VSS VSS sg13_lv_nmos w=3.2e-07 l=1.3e-07 ng=1
MP2 Y n2 VDD VDD sg13_lv_pmos w=4.9e-07 l=1.3e-07 ng=1
MN3 n3 n0 n4 VSS sg13_lv_nmos w=3e-07 l=1.3e-07 ng=1
MN4 n4 I0 VSS VSS sg13_lv_nmos w=3e-07 l=1.3e-07 ng=1
MP3 n3 S0 n5 VDD sg13_lv_pmos w=4.5e-07 l=1.3e-07 ng=1
MP4 n5 I0 VDD VDD sg13_lv_pmos w=4.5e-07 l=1.3e-07 ng=1
MN5 n3 S0 n6 VSS sg13_lv_nmos w=3e-07 l=1.3e-07 ng=1
MN6 n6 I1 VSS VSS sg13_lv_nmos w=3e-07 l=1.3e-07 ng=1
MP5 n3 n0 n7 VDD sg13_lv_pmos w=4.5e-07 l=1.3e-07 ng=1
MP6 n7 I1 VDD VDD sg13_lv_pmos w=4.5e-07 l=1.3e-07 ng=1
MN7 n8 n0 n9 VSS sg13_lv_nmos w=3e-07 l=1.3e-07 ng=1
MN8 n9 I2 VSS VSS sg13_lv_nmos w=3e-07 l=1.3e-07 ng=1
MP7 n8 S0 n10 VDD sg13_lv_pmos w=4.5e-07 l=1.3e-07 ng=1
MP8 n10 I2 VDD VDD sg13_lv_pmos w=4.5e-07 l=1.3e-07 ng=1
MN9 n8 S0 n11 VSS sg13_lv_nmos w=3e-07 l=1.3e-07 ng=1
MN10 n11 I3 VSS VSS sg13_lv_nmos w=3e-07 l=1.3e-07 ng=1
MP9 n8 n0 n12 VDD sg13_lv_pmos w=4.5e-07 l=1.3e-07 ng=1
MP10 n12 I3 VDD VDD sg13_lv_pmos w=4.5e-07 l=1.3e-07 ng=1
MN11 n3 n1 n2 VSS sg13_lv_nmos w=3e-07 l=1.3e-07 ng=1
MP11 n3 S1 n2 VDD sg13_lv_pmos w=9e-07 l=1.3e-07 ng=1
MN12 n8 S1 n2 VSS sg13_lv_nmos w=3e-07 l=1.3e-07 ng=1
MP12 n8 n1 n2 VDD sg13_lv_pmos w=9e-07 l=1.3e-07 ng=1
.ENDS

****************************************
* Cell : NAND2_D1
* Description : Two input NAND gate
* Reduced truth table for output Y
* ┌─────┬─────┬─────┐
* │ A   │ B   │   Y │
* ├─────┼─────┼─────┤
* │ 0   │ -   │   1 │
* ├─────┼─────┼─────┤
* │ -   │ 0   │   1 │
* ├─────┼─────┼─────┤
* │ 1   │ 1   │   0 │
* └─────┴─────┴─────┘
****************************************
.SUBCKT NAND2_D1 A B Y VDD VSS
*.PININFO A:I B:I Y:O VDD:B VSS:B
MN0 n0 A VSS VSS sg13_lv_nmos w=9e-07 l=1.3e-07 ng=1
MN1 Y B n0 VSS sg13_lv_nmos w=9e-07 l=1.3e-07 ng=1
MP0 Y A VDD VDD sg13_lv_pmos w=9.8e-07 l=1.3e-07 ng=1
MP1 Y B VDD VDD sg13_lv_pmos w=9.8e-07 l=1.3e-07 ng=1
.ENDS

****************************************
* Cell : NAND2_D2
* Description : Two input NAND gate
* Reduced truth table for output Y
* ┌─────┬─────┬─────┐
* │ A   │ B   │   Y │
* ├─────┼─────┼─────┤
* │ 0   │ -   │   1 │
* ├─────┼─────┼─────┤
* │ -   │ 0   │   1 │
* ├─────┼─────┼─────┤
* │ 1   │ 1   │   0 │
* └─────┴─────┴─────┘
****************************************
.SUBCKT NAND2_D2 A B Y VDD VSS
*.PININFO A:I B:I Y:O VDD:B VSS:B
MN0 n0 B VSS VSS sg13_lv_nmos w=7.25e-07 l=1.3e-07 ng=1
MN1 Y A n0 VSS sg13_lv_nmos w=7.25e-07 l=1.3e-07 ng=1
MN2 n1 B VSS VSS sg13_lv_nmos w=7.25e-07 l=1.3e-07 ng=1
MN3 Y A n1 VSS sg13_lv_nmos w=7.25e-07 l=1.3e-07 ng=1
MP0 Y A VDD VDD sg13_lv_pmos w=1.6e-06 l=1.3e-07 ng=1
MP1 Y B VDD VDD sg13_lv_pmos w=1.6e-06 l=1.3e-07 ng=1
.ENDS

****************************************
* Cell : NAND2_D4
* Description : Two input NAND gate
* Reduced truth table for output Y
* ┌─────┬─────┬─────┐
* │ A   │ B   │   Y │
* ├─────┼─────┼─────┤
* │ 0   │ -   │   1 │
* ├─────┼─────┼─────┤
* │ -   │ 0   │   1 │
* ├─────┼─────┼─────┤
* │ 1   │ 1   │   0 │
* └─────┴─────┴─────┘
****************************************
.SUBCKT NAND2_D4 A B Y VDD VSS
*.PININFO A:I B:I Y:O VDD:B VSS:B
MN0 n0 B VSS VSS sg13_lv_nmos w=1.07e-06 l=1.3e-07 ng=1
MN1 Y A n0 VSS sg13_lv_nmos w=1.07e-06 l=1.3e-07 ng=1
MN2 n1 B VSS VSS sg13_lv_nmos w=1.07e-06 l=1.3e-07 ng=1
MN3 Y A n1 VSS sg13_lv_nmos w=1.07e-06 l=1.3e-07 ng=1
MN4 n2 B VSS VSS sg13_lv_nmos w=1.07e-06 l=1.3e-07 ng=1
MN5 Y A n2 VSS sg13_lv_nmos w=1.07e-06 l=1.3e-07 ng=1
MP0 Y A VDD VDD sg13_lv_pmos w=1.6e-06 l=1.3e-07 ng=1
MP1 Y B VDD VDD sg13_lv_pmos w=1.6e-06 l=1.3e-07 ng=1
MP2 Y A VDD VDD sg13_lv_pmos w=1.6e-06 l=1.3e-07 ng=1
MP3 Y B VDD VDD sg13_lv_pmos w=1.6e-06 l=1.3e-07 ng=1
.ENDS

****************************************
* Cell : NAND2_D8
* Description : Two input NAND gate
* Reduced truth table for output Y
* ┌─────┬─────┬─────┐
* │ A   │ B   │   Y │
* ├─────┼─────┼─────┤
* │ 0   │ -   │   1 │
* ├─────┼─────┼─────┤
* │ -   │ 0   │   1 │
* ├─────┼─────┼─────┤
* │ 1   │ 1   │   0 │
* └─────┴─────┴─────┘
****************************************
.SUBCKT NAND2_D8 A B Y VDD VSS
*.PININFO A:I B:I Y:O VDD:B VSS:B
MN0 n0 B VSS VSS sg13_lv_nmos w=1.07e-06 l=1.3e-07 ng=1
MN1 Y A n0 VSS sg13_lv_nmos w=1.07e-06 l=1.3e-07 ng=1
MN2 n1 B VSS VSS sg13_lv_nmos w=1.07e-06 l=1.3e-07 ng=1
MN3 Y A n1 VSS sg13_lv_nmos w=1.07e-06 l=1.3e-07 ng=1
MN4 n2 B VSS VSS sg13_lv_nmos w=1.07e-06 l=1.3e-07 ng=1
MN5 Y A n2 VSS sg13_lv_nmos w=1.07e-06 l=1.3e-07 ng=1
MN6 n3 B VSS VSS sg13_lv_nmos w=1.07e-06 l=1.3e-07 ng=1
MN7 Y A n3 VSS sg13_lv_nmos w=1.07e-06 l=1.3e-07 ng=1
MN8 n4 B VSS VSS sg13_lv_nmos w=1.07e-06 l=1.3e-07 ng=1
MN9 Y A n4 VSS sg13_lv_nmos w=1.07e-06 l=1.3e-07 ng=1
MN10 n5 B VSS VSS sg13_lv_nmos w=1.07e-06 l=1.3e-07 ng=1
MN11 Y A n5 VSS sg13_lv_nmos w=1.07e-06 l=1.3e-07 ng=1
MP0 Y A VDD VDD sg13_lv_pmos w=1.6e-06 l=1.3e-07 ng=1
MP1 Y B VDD VDD sg13_lv_pmos w=1.6e-06 l=1.3e-07 ng=1
MP2 Y A VDD VDD sg13_lv_pmos w=1.6e-06 l=1.3e-07 ng=1
MP3 Y B VDD VDD sg13_lv_pmos w=1.6e-06 l=1.3e-07 ng=1
MP4 Y A VDD VDD sg13_lv_pmos w=1.6e-06 l=1.3e-07 ng=1
MP5 Y B VDD VDD sg13_lv_pmos w=1.6e-06 l=1.3e-07 ng=1
.ENDS

****************************************
* Cell : NAND2_DL
* Description : Two input NAND gate
* Reduced truth table for output Y
* ┌─────┬─────┬─────┐
* │ A   │ B   │   Y │
* ├─────┼─────┼─────┤
* │ 0   │ -   │   1 │
* ├─────┼─────┼─────┤
* │ -   │ 0   │   1 │
* ├─────┼─────┼─────┤
* │ 1   │ 1   │   0 │
* └─────┴─────┴─────┘
****************************************
.SUBCKT NAND2_DL A B Y VDD VSS
*.PININFO A:I B:I Y:O VDD:B VSS:B
MN0 n0 A VSS VSS sg13_lv_nmos w=4.5e-07 l=1.3e-07 ng=1
MN1 Y B n0 VSS sg13_lv_nmos w=4.5e-07 l=1.3e-07 ng=1
MP0 Y A VDD VDD sg13_lv_pmos w=4.9e-07 l=1.3e-07 ng=1
MP1 Y B VDD VDD sg13_lv_pmos w=4.9e-07 l=1.3e-07 ng=1
.ENDS

****************************************
* Cell : NAND3_D1
* Description : Three input NAND gate
* Reduced truth table for output Y
* ┌─────┬─────┬─────┬─────┐
* │ A   │ B   │ C   │   Y │
* ├─────┼─────┼─────┼─────┤
* │ 0   │ -   │ -   │   1 │
* ├─────┼─────┼─────┼─────┤
* │ -   │ 0   │ -   │   1 │
* ├─────┼─────┼─────┼─────┤
* │ -   │ -   │ 0   │   1 │
* ├─────┼─────┼─────┼─────┤
* │ 1   │ 1   │ 1   │   0 │
* └─────┴─────┴─────┴─────┘
****************************************
.SUBCKT NAND3_D1 A B C Y VDD VSS
*.PININFO A:I B:I C:I Y:O VDD:B VSS:B
MN0 n0 C VSS VSS sg13_lv_nmos w=1.03e-06 l=1.3e-07 ng=1
MN1 n1 B n0 VSS sg13_lv_nmos w=1.03e-06 l=1.3e-07 ng=1
MN2 Y A n1 VSS sg13_lv_nmos w=1.03e-06 l=1.3e-07 ng=1
MP0 Y A VDD VDD sg13_lv_pmos w=9.8e-07 l=1.3e-07 ng=1
MP1 Y B VDD VDD sg13_lv_pmos w=9.8e-07 l=1.3e-07 ng=1
MP2 Y C VDD VDD sg13_lv_pmos w=9.8e-07 l=1.3e-07 ng=1
.ENDS

****************************************
* Cell : NAND3_D2
* Description : Three input NAND gate
* Reduced truth table for output Y
* ┌─────┬─────┬─────┬─────┐
* │ A   │ B   │ C   │   Y │
* ├─────┼─────┼─────┼─────┤
* │ 0   │ -   │ -   │   1 │
* ├─────┼─────┼─────┼─────┤
* │ -   │ 0   │ -   │   1 │
* ├─────┼─────┼─────┼─────┤
* │ -   │ -   │ 0   │   1 │
* ├─────┼─────┼─────┼─────┤
* │ 1   │ 1   │ 1   │   0 │
* └─────┴─────┴─────┴─────┘
****************************************
.SUBCKT NAND3_D2 A B C Y VDD VSS
*.PININFO A:I B:I C:I Y:O VDD:B VSS:B
MN0 n0 C VSS VSS sg13_lv_nmos w=1.03e-06 l=1.3e-07 ng=1
MN1 n1 B n0 VSS sg13_lv_nmos w=1.03e-06 l=1.3e-07 ng=1
MN2 Y A n1 VSS sg13_lv_nmos w=1.03e-06 l=1.3e-07 ng=1
MP0 Y A VDD VDD sg13_lv_pmos w=9.8e-07 l=1.3e-07 ng=1
MP1 Y B VDD VDD sg13_lv_pmos w=9.8e-07 l=1.3e-07 ng=1
MP2 Y C VDD VDD sg13_lv_pmos w=9.8e-07 l=1.3e-07 ng=1
MN3 n2 C VSS VSS sg13_lv_nmos w=1.03e-06 l=1.3e-07 ng=1
MN4 n3 B n2 VSS sg13_lv_nmos w=1.03e-06 l=1.3e-07 ng=1
MN5 Y A n3 VSS sg13_lv_nmos w=1.03e-06 l=1.3e-07 ng=1
MP3 Y A VDD VDD sg13_lv_pmos w=9.8e-07 l=1.3e-07 ng=1
MP4 Y B VDD VDD sg13_lv_pmos w=9.8e-07 l=1.3e-07 ng=1
MP5 Y C VDD VDD sg13_lv_pmos w=9.8e-07 l=1.3e-07 ng=1
.ENDS

****************************************
* Cell : NAND3_D4
* Description : Three input NAND gate
* Reduced truth table for output Y
* ┌─────┬─────┬─────┬─────┐
* │ A   │ B   │ C   │   Y │
* ├─────┼─────┼─────┼─────┤
* │ 0   │ -   │ -   │   1 │
* ├─────┼─────┼─────┼─────┤
* │ -   │ 0   │ -   │   1 │
* ├─────┼─────┼─────┼─────┤
* │ -   │ -   │ 0   │   1 │
* ├─────┼─────┼─────┼─────┤
* │ 1   │ 1   │ 1   │   0 │
* └─────┴─────┴─────┴─────┘
****************************************
.SUBCKT NAND3_D4 A B C Y VDD VSS
*.PININFO A:I B:I C:I Y:O VDD:B VSS:B
MN0 n0 C VSS VSS sg13_lv_nmos w=1.03e-06 l=1.3e-07 ng=1
MN1 n1 B n0 VSS sg13_lv_nmos w=1.03e-06 l=1.3e-07 ng=1
MN2 Y A n1 VSS sg13_lv_nmos w=1.03e-06 l=1.3e-07 ng=1
MP0 Y A VDD VDD sg13_lv_pmos w=9.8e-07 l=1.3e-07 ng=1
MP1 Y B VDD VDD sg13_lv_pmos w=9.8e-07 l=1.3e-07 ng=1
MP2 Y C VDD VDD sg13_lv_pmos w=9.8e-07 l=1.3e-07 ng=1
MN3 n2 C VSS VSS sg13_lv_nmos w=1.03e-06 l=1.3e-07 ng=1
MN4 n3 B n2 VSS sg13_lv_nmos w=1.03e-06 l=1.3e-07 ng=1
MN5 Y A n3 VSS sg13_lv_nmos w=1.03e-06 l=1.3e-07 ng=1
MP3 Y A VDD VDD sg13_lv_pmos w=9.8e-07 l=1.3e-07 ng=1
MP4 Y B VDD VDD sg13_lv_pmos w=9.8e-07 l=1.3e-07 ng=1
MP5 Y C VDD VDD sg13_lv_pmos w=9.8e-07 l=1.3e-07 ng=1
MN6 n4 C VSS VSS sg13_lv_nmos w=1.03e-06 l=1.3e-07 ng=1
MN7 n5 B n4 VSS sg13_lv_nmos w=1.03e-06 l=1.3e-07 ng=1
MN8 Y A n5 VSS sg13_lv_nmos w=1.03e-06 l=1.3e-07 ng=1
MP6 Y A VDD VDD sg13_lv_pmos w=9.8e-07 l=1.3e-07 ng=1
MP7 Y B VDD VDD sg13_lv_pmos w=9.8e-07 l=1.3e-07 ng=1
MP8 Y C VDD VDD sg13_lv_pmos w=9.8e-07 l=1.3e-07 ng=1
MN9 n6 C VSS VSS sg13_lv_nmos w=1.03e-06 l=1.3e-07 ng=1
MN10 n7 B n6 VSS sg13_lv_nmos w=1.03e-06 l=1.3e-07 ng=1
MN11 Y A n7 VSS sg13_lv_nmos w=1.03e-06 l=1.3e-07 ng=1
MP9 Y A VDD VDD sg13_lv_pmos w=9.8e-07 l=1.3e-07 ng=1
MP10 Y B VDD VDD sg13_lv_pmos w=9.8e-07 l=1.3e-07 ng=1
MP11 Y C VDD VDD sg13_lv_pmos w=9.8e-07 l=1.3e-07 ng=1
.ENDS

****************************************
* Cell : NAND3_DL
* Description : Three input NAND gate
* Reduced truth table for output Y
* ┌─────┬─────┬─────┬─────┐
* │ A   │ B   │ C   │   Y │
* ├─────┼─────┼─────┼─────┤
* │ 0   │ -   │ -   │   1 │
* ├─────┼─────┼─────┼─────┤
* │ -   │ 0   │ -   │   1 │
* ├─────┼─────┼─────┼─────┤
* │ -   │ -   │ 0   │   1 │
* ├─────┼─────┼─────┼─────┤
* │ 1   │ 1   │ 1   │   0 │
* └─────┴─────┴─────┴─────┘
****************************************
.SUBCKT NAND3_DL A B C Y VDD VSS
*.PININFO A:I B:I C:I Y:O VDD:B VSS:B
MN0 n0 C VSS VSS sg13_lv_nmos w=5.2e-07 l=1.3e-07 ng=1
MN1 n1 B n0 VSS sg13_lv_nmos w=5.2e-07 l=1.3e-07 ng=1
MN2 Y A n1 VSS sg13_lv_nmos w=5.2e-07 l=1.3e-07 ng=1
MP0 Y A VDD VDD sg13_lv_pmos w=4.9e-07 l=1.3e-07 ng=1
MP1 Y B VDD VDD sg13_lv_pmos w=4.9e-07 l=1.3e-07 ng=1
MP2 Y C VDD VDD sg13_lv_pmos w=4.9e-07 l=1.3e-07 ng=1
.ENDS

****************************************
* Cell : NAND4N1_D1
* Description : Four input NAND gate with one input inverted
* Reduced truth table for output Y
* ┌──────┬─────┬─────┬─────┬─────┐
* │ AN   │ B   │ C   │ D   │   Y │
* ├──────┼─────┼─────┼─────┼─────┤
* │ 1    │ -   │ -   │ -   │   1 │
* ├──────┼─────┼─────┼─────┼─────┤
* │ -    │ 0   │ -   │ -   │   1 │
* ├──────┼─────┼─────┼─────┼─────┤
* │ -    │ -   │ 0   │ -   │   1 │
* ├──────┼─────┼─────┼─────┼─────┤
* │ -    │ -   │ -   │ 0   │   1 │
* ├──────┼─────┼─────┼─────┼─────┤
* │ 0    │ 1   │ 1   │ 1   │   0 │
* └──────┴─────┴─────┴─────┴─────┘
****************************************
.SUBCKT NAND4N1_D1 AN B C D Y VDD VSS
*.PININFO AN:I B:I C:I D:I Y:O VDD:B VSS:B
MN0 n0 D VSS VSS sg13_lv_nmos w=8e-07 l=1.3e-07 ng=1
MN1 n1 C n0 VSS sg13_lv_nmos w=8e-07 l=1.3e-07 ng=1
MN2 n2 B n1 VSS sg13_lv_nmos w=8e-07 l=1.3e-07 ng=1
MN3 Y n3 n2 VSS sg13_lv_nmos w=8e-07 l=1.3e-07 ng=1
MP0 Y n3 VDD VDD sg13_lv_pmos w=7e-07 l=1.3e-07 ng=1
MP1 Y B VDD VDD sg13_lv_pmos w=7e-07 l=1.3e-07 ng=1
MP2 Y C VDD VDD sg13_lv_pmos w=7e-07 l=1.3e-07 ng=1
MP3 Y D VDD VDD sg13_lv_pmos w=7e-07 l=1.3e-07 ng=1
MN4 n3 AN VSS VSS sg13_lv_nmos w=2e-07 l=1.3e-07 ng=1
MP4 n3 AN VDD VDD sg13_lv_pmos w=3e-07 l=1.3e-07 ng=1
.ENDS

****************************************
* Cell : NAND4N1_D2
* Description : Four input NAND gate with one input inverted
* Reduced truth table for output Y
* ┌──────┬─────┬─────┬─────┬─────┐
* │ AN   │ B   │ C   │ D   │   Y │
* ├──────┼─────┼─────┼─────┼─────┤
* │ 1    │ -   │ -   │ -   │   1 │
* ├──────┼─────┼─────┼─────┼─────┤
* │ -    │ 0   │ -   │ -   │   1 │
* ├──────┼─────┼─────┼─────┼─────┤
* │ -    │ -   │ 0   │ -   │   1 │
* ├──────┼─────┼─────┼─────┼─────┤
* │ -    │ -   │ -   │ 0   │   1 │
* ├──────┼─────┼─────┼─────┼─────┤
* │ 0    │ 1   │ 1   │ 1   │   0 │
* └──────┴─────┴─────┴─────┴─────┘
****************************************
.SUBCKT NAND4N1_D2 AN B C D Y VDD VSS
*.PININFO AN:I B:I C:I D:I Y:O VDD:B VSS:B
MN0 n0 D VSS VSS sg13_lv_nmos w=1.4e-06 l=1.3e-07 ng=2
MN1 n1 C n0 VSS sg13_lv_nmos w=1.4e-06 l=1.3e-07 ng=2
MN2 n2 B n1 VSS sg13_lv_nmos w=1.4e-06 l=1.3e-07 ng=2
MN3 Y n3 n2 VSS sg13_lv_nmos w=1.4e-06 l=1.3e-07 ng=2
MP0 Y n3 VDD VDD sg13_lv_pmos w=1.2e-06 l=1.3e-07 ng=1
MP1 Y B VDD VDD sg13_lv_pmos w=1.2e-06 l=1.3e-07 ng=1
MP2 Y C VDD VDD sg13_lv_pmos w=1.2e-06 l=1.3e-07 ng=1
MP3 Y D VDD VDD sg13_lv_pmos w=1.2e-06 l=1.3e-07 ng=1
MN4 n3 AN VSS VSS sg13_lv_nmos w=4e-07 l=1.3e-07 ng=1
MP4 n3 AN VDD VDD sg13_lv_pmos w=6e-07 l=1.3e-07 ng=1
.ENDS

****************************************
* Cell : NAND4N1_DL
* Description : Four input NAND gate with one input inverted
* Reduced truth table for output Y
* ┌──────┬─────┬─────┬─────┬─────┐
* │ AN   │ B   │ C   │ D   │   Y │
* ├──────┼─────┼─────┼─────┼─────┤
* │ 1    │ -   │ -   │ -   │   1 │
* ├──────┼─────┼─────┼─────┼─────┤
* │ -    │ 0   │ -   │ -   │   1 │
* ├──────┼─────┼─────┼─────┼─────┤
* │ -    │ -   │ 0   │ -   │   1 │
* ├──────┼─────┼─────┼─────┼─────┤
* │ -    │ -   │ -   │ 0   │   1 │
* ├──────┼─────┼─────┼─────┼─────┤
* │ 0    │ 1   │ 1   │ 1   │   0 │
* └──────┴─────┴─────┴─────┴─────┘
****************************************
.SUBCKT NAND4N1_DL AN B C D Y VDD VSS
*.PININFO AN:I B:I C:I D:I Y:O VDD:B VSS:B
MN0 n0 D VSS VSS sg13_lv_nmos w=3.6e-07 l=1.3e-07 ng=1
MN1 n1 C n0 VSS sg13_lv_nmos w=3.6e-07 l=1.3e-07 ng=1
MN2 n2 B n1 VSS sg13_lv_nmos w=3.6e-07 l=1.3e-07 ng=1
MN3 Y n3 n2 VSS sg13_lv_nmos w=3.6e-07 l=1.3e-07 ng=1
MP0 Y n3 VDD VDD sg13_lv_pmos w=3e-07 l=1.3e-07 ng=1
MP1 Y B VDD VDD sg13_lv_pmos w=3e-07 l=1.3e-07 ng=1
MP2 Y C VDD VDD sg13_lv_pmos w=3e-07 l=1.3e-07 ng=1
MP3 Y D VDD VDD sg13_lv_pmos w=3e-07 l=1.3e-07 ng=1
MN4 n3 AN VSS VSS sg13_lv_nmos w=1.5e-07 l=1.3e-07 ng=1
MP4 n3 AN VDD VDD sg13_lv_pmos w=2.3e-07 l=1.3e-07 ng=1
.ENDS

****************************************
* Cell : NAND4N2_D1
* Description : Four input NAND gate with two inputs inverted
* Reduced truth table for output Y
* ┌──────┬──────┬─────┬─────┬─────┐
* │ AN   │ BN   │ C   │ D   │   Y │
* ├──────┼──────┼─────┼─────┼─────┤
* │ 1    │ -    │ -   │ -   │   1 │
* ├──────┼──────┼─────┼─────┼─────┤
* │ -    │ 1    │ -   │ -   │   1 │
* ├──────┼──────┼─────┼─────┼─────┤
* │ -    │ -    │ 0   │ -   │   1 │
* ├──────┼──────┼─────┼─────┼─────┤
* │ -    │ -    │ -   │ 0   │   1 │
* ├──────┼──────┼─────┼─────┼─────┤
* │ 0    │ 0    │ 1   │ 1   │   0 │
* └──────┴──────┴─────┴─────┴─────┘
****************************************
.SUBCKT NAND4N2_D1 AN BN C D Y VDD VSS
*.PININFO AN:I BN:I C:I D:I Y:O VDD:B VSS:B
MN0 n0 D VSS VSS sg13_lv_nmos w=8e-07 l=1.3e-07 ng=1
MN1 n1 C n0 VSS sg13_lv_nmos w=8e-07 l=1.3e-07 ng=1
MN2 n2 n3 n1 VSS sg13_lv_nmos w=8e-07 l=1.3e-07 ng=1
MN3 Y n4 n2 VSS sg13_lv_nmos w=8e-07 l=1.3e-07 ng=1
MP0 Y n4 VDD VDD sg13_lv_pmos w=7e-07 l=1.3e-07 ng=1
MP1 Y n3 VDD VDD sg13_lv_pmos w=7e-07 l=1.3e-07 ng=1
MP2 Y C VDD VDD sg13_lv_pmos w=7e-07 l=1.3e-07 ng=1
MP3 Y D VDD VDD sg13_lv_pmos w=7e-07 l=1.3e-07 ng=1
MN4 n4 AN VSS VSS sg13_lv_nmos w=2e-07 l=1.3e-07 ng=1
MP4 n4 AN VDD VDD sg13_lv_pmos w=3e-07 l=1.3e-07 ng=1
MN5 n3 BN VSS VSS sg13_lv_nmos w=2e-07 l=1.3e-07 ng=1
MP5 n3 BN VDD VDD sg13_lv_pmos w=3e-07 l=1.3e-07 ng=1
.ENDS

****************************************
* Cell : NAND4N2_D2
* Description : Four input NAND gate with two inputs inverted
* Reduced truth table for output Y
* ┌──────┬──────┬─────┬─────┬─────┐
* │ AN   │ BN   │ C   │ D   │   Y │
* ├──────┼──────┼─────┼─────┼─────┤
* │ 1    │ -    │ -   │ -   │   1 │
* ├──────┼──────┼─────┼─────┼─────┤
* │ -    │ 1    │ -   │ -   │   1 │
* ├──────┼──────┼─────┼─────┼─────┤
* │ -    │ -    │ 0   │ -   │   1 │
* ├──────┼──────┼─────┼─────┼─────┤
* │ -    │ -    │ -   │ 0   │   1 │
* ├──────┼──────┼─────┼─────┼─────┤
* │ 0    │ 0    │ 1   │ 1   │   0 │
* └──────┴──────┴─────┴─────┴─────┘
****************************************
.SUBCKT NAND4N2_D2 AN BN C D Y VDD VSS
*.PININFO AN:I BN:I C:I D:I Y:O VDD:B VSS:B
MN0 n0 D VSS VSS sg13_lv_nmos w=1.4e-06 l=1.3e-07 ng=2
MN1 n1 C n0 VSS sg13_lv_nmos w=1.4e-06 l=1.3e-07 ng=2
MN2 n2 n3 n1 VSS sg13_lv_nmos w=1.4e-06 l=1.3e-07 ng=2
MN3 Y n4 n2 VSS sg13_lv_nmos w=1.4e-06 l=1.3e-07 ng=2
MP0 Y n4 VDD VDD sg13_lv_pmos w=1.2e-06 l=1.3e-07 ng=1
MP1 Y n3 VDD VDD sg13_lv_pmos w=1.2e-06 l=1.3e-07 ng=1
MP2 Y C VDD VDD sg13_lv_pmos w=1.2e-06 l=1.3e-07 ng=1
MP3 Y D VDD VDD sg13_lv_pmos w=1.2e-06 l=1.3e-07 ng=1
MN4 n4 AN VSS VSS sg13_lv_nmos w=4e-07 l=1.3e-07 ng=1
MP4 n4 AN VDD VDD sg13_lv_pmos w=6e-07 l=1.3e-07 ng=1
MN5 n3 BN VSS VSS sg13_lv_nmos w=4e-07 l=1.3e-07 ng=1
MP5 n3 BN VDD VDD sg13_lv_pmos w=6e-07 l=1.3e-07 ng=1
.ENDS

****************************************
* Cell : NAND4N2_DL
* Description : Four input NAND gate with two inputs inverted
* Reduced truth table for output Y
* ┌──────┬──────┬─────┬─────┬─────┐
* │ AN   │ BN   │ C   │ D   │   Y │
* ├──────┼──────┼─────┼─────┼─────┤
* │ 1    │ -    │ -   │ -   │   1 │
* ├──────┼──────┼─────┼─────┼─────┤
* │ -    │ 1    │ -   │ -   │   1 │
* ├──────┼──────┼─────┼─────┼─────┤
* │ -    │ -    │ 0   │ -   │   1 │
* ├──────┼──────┼─────┼─────┼─────┤
* │ -    │ -    │ -   │ 0   │   1 │
* ├──────┼──────┼─────┼─────┼─────┤
* │ 0    │ 0    │ 1   │ 1   │   0 │
* └──────┴──────┴─────┴─────┴─────┘
****************************************
.SUBCKT NAND4N2_DL AN BN C D Y VDD VSS
*.PININFO AN:I BN:I C:I D:I Y:O VDD:B VSS:B
MN0 n0 D VSS VSS sg13_lv_nmos w=3.8e-07 l=1.3e-07 ng=1
MN1 n1 C n0 VSS sg13_lv_nmos w=3.8e-07 l=1.3e-07 ng=1
MN2 n2 n3 n1 VSS sg13_lv_nmos w=3.8e-07 l=1.3e-07 ng=1
MN3 Y n4 n2 VSS sg13_lv_nmos w=3.8e-07 l=1.3e-07 ng=1
MP0 Y n4 VDD VDD sg13_lv_pmos w=3e-07 l=1.3e-07 ng=1
MP1 Y n3 VDD VDD sg13_lv_pmos w=3e-07 l=1.3e-07 ng=1
MP2 Y C VDD VDD sg13_lv_pmos w=3e-07 l=1.3e-07 ng=1
MP3 Y D VDD VDD sg13_lv_pmos w=3e-07 l=1.3e-07 ng=1
MN4 n4 AN VSS VSS sg13_lv_nmos w=1.5e-07 l=1.3e-07 ng=1
MP4 n4 AN VDD VDD sg13_lv_pmos w=2.3e-07 l=1.3e-07 ng=1
MN5 n3 BN VSS VSS sg13_lv_nmos w=1.5e-07 l=1.3e-07 ng=1
MP5 n3 BN VDD VDD sg13_lv_pmos w=2.3e-07 l=1.3e-07 ng=1
.ENDS

****************************************
* Cell : NAND4_D1
* Description : Four input NAND gate
* Reduced truth table for output Y
* ┌─────┬─────┬─────┬─────┬─────┐
* │ A   │ B   │ C   │ D   │   Y │
* ├─────┼─────┼─────┼─────┼─────┤
* │ 0   │ -   │ -   │ -   │   1 │
* ├─────┼─────┼─────┼─────┼─────┤
* │ -   │ 0   │ -   │ -   │   1 │
* ├─────┼─────┼─────┼─────┼─────┤
* │ -   │ -   │ 0   │ -   │   1 │
* ├─────┼─────┼─────┼─────┼─────┤
* │ -   │ -   │ -   │ 0   │   1 │
* ├─────┼─────┼─────┼─────┼─────┤
* │ 1   │ 1   │ 1   │ 1   │   0 │
* └─────┴─────┴─────┴─────┴─────┘
****************************************
.SUBCKT NAND4_D1 A B C D Y VDD VSS
*.PININFO A:I B:I C:I D:I Y:O VDD:B VSS:B
MN0 n0 D VSS VSS sg13_lv_nmos w=8e-07 l=1.3e-07 ng=1
MN1 n1 C n0 VSS sg13_lv_nmos w=8e-07 l=1.3e-07 ng=1
MN2 n2 B n1 VSS sg13_lv_nmos w=8e-07 l=1.3e-07 ng=1
MN3 Y A n2 VSS sg13_lv_nmos w=8e-07 l=1.3e-07 ng=1
MP0 Y A VDD VDD sg13_lv_pmos w=7e-07 l=1.3e-07 ng=1
MP1 Y B VDD VDD sg13_lv_pmos w=7e-07 l=1.3e-07 ng=1
MP2 Y C VDD VDD sg13_lv_pmos w=7e-07 l=1.3e-07 ng=1
MP3 Y D VDD VDD sg13_lv_pmos w=7e-07 l=1.3e-07 ng=1
.ENDS

****************************************
* Cell : NAND4_D2
* Description : Four input NAND gate
* Reduced truth table for output Y
* ┌─────┬─────┬─────┬─────┬─────┐
* │ A   │ B   │ C   │ D   │   Y │
* ├─────┼─────┼─────┼─────┼─────┤
* │ 0   │ -   │ -   │ -   │   1 │
* ├─────┼─────┼─────┼─────┼─────┤
* │ -   │ 0   │ -   │ -   │   1 │
* ├─────┼─────┼─────┼─────┼─────┤
* │ -   │ -   │ 0   │ -   │   1 │
* ├─────┼─────┼─────┼─────┼─────┤
* │ -   │ -   │ -   │ 0   │   1 │
* ├─────┼─────┼─────┼─────┼─────┤
* │ 1   │ 1   │ 1   │ 1   │   0 │
* └─────┴─────┴─────┴─────┴─────┘
****************************************
.SUBCKT NAND4_D2 A B C D Y VDD VSS
*.PININFO A:I B:I C:I D:I Y:O VDD:B VSS:B
MN0 n0 D VSS VSS sg13_lv_nmos w=1.4e-06 l=1.3e-07 ng=2
MN1 n1 C n0 VSS sg13_lv_nmos w=1.4e-06 l=1.3e-07 ng=2
MN2 n2 B n1 VSS sg13_lv_nmos w=1.4e-06 l=1.3e-07 ng=2
MN3 Y A n2 VSS sg13_lv_nmos w=1.4e-06 l=1.3e-07 ng=2
MP0 Y A VDD VDD sg13_lv_pmos w=1.2e-06 l=1.3e-07 ng=1
MP1 Y B VDD VDD sg13_lv_pmos w=1.2e-06 l=1.3e-07 ng=1
MP2 Y C VDD VDD sg13_lv_pmos w=1.2e-06 l=1.3e-07 ng=1
MP3 Y D VDD VDD sg13_lv_pmos w=1.2e-06 l=1.3e-07 ng=1
.ENDS

****************************************
* Cell : NAND4_D4
* Description : Four input NAND gate
* Reduced truth table for output Y
* ┌─────┬─────┬─────┬─────┬─────┐
* │ A   │ B   │ C   │ D   │   Y │
* ├─────┼─────┼─────┼─────┼─────┤
* │ 0   │ -   │ -   │ -   │   1 │
* ├─────┼─────┼─────┼─────┼─────┤
* │ -   │ 0   │ -   │ -   │   1 │
* ├─────┼─────┼─────┼─────┼─────┤
* │ -   │ -   │ 0   │ -   │   1 │
* ├─────┼─────┼─────┼─────┼─────┤
* │ -   │ -   │ -   │ 0   │   1 │
* ├─────┼─────┼─────┼─────┼─────┤
* │ 1   │ 1   │ 1   │ 1   │   0 │
* └─────┴─────┴─────┴─────┴─────┘
****************************************
.SUBCKT NAND4_D4 A B C D Y VDD VSS
*.PININFO A:I B:I C:I D:I Y:O VDD:B VSS:B
MN0 n0 D VSS VSS sg13_lv_nmos w=3.18e-06 l=1.3e-07 ng=3
MN1 n1 C n0 VSS sg13_lv_nmos w=3.18e-06 l=1.3e-07 ng=3
MN2 n2 B n1 VSS sg13_lv_nmos w=3.18e-06 l=1.3e-07 ng=3
MN3 Y A n2 VSS sg13_lv_nmos w=3.18e-06 l=1.3e-07 ng=3
MP0 Y A VDD VDD sg13_lv_pmos w=2.6e-06 l=1.3e-07 ng=2
MP1 Y B VDD VDD sg13_lv_pmos w=2.6e-06 l=1.3e-07 ng=2
MP2 Y C VDD VDD sg13_lv_pmos w=2.6e-06 l=1.3e-07 ng=2
MP3 Y D VDD VDD sg13_lv_pmos w=2.6e-06 l=1.3e-07 ng=2
.ENDS

****************************************
* Cell : NAND4_DL
* Description : Four input NAND gate
* Reduced truth table for output Y
* ┌─────┬─────┬─────┬─────┬─────┐
* │ A   │ B   │ C   │ D   │   Y │
* ├─────┼─────┼─────┼─────┼─────┤
* │ 0   │ -   │ -   │ -   │   1 │
* ├─────┼─────┼─────┼─────┼─────┤
* │ -   │ 0   │ -   │ -   │   1 │
* ├─────┼─────┼─────┼─────┼─────┤
* │ -   │ -   │ 0   │ -   │   1 │
* ├─────┼─────┼─────┼─────┼─────┤
* │ -   │ -   │ -   │ 0   │   1 │
* ├─────┼─────┼─────┼─────┼─────┤
* │ 1   │ 1   │ 1   │ 1   │   0 │
* └─────┴─────┴─────┴─────┴─────┘
****************************************
.SUBCKT NAND4_DL A B C D Y VDD VSS
*.PININFO A:I B:I C:I D:I Y:O VDD:B VSS:B
MN0 n0 D VSS VSS sg13_lv_nmos w=4.5e-07 l=1.3e-07 ng=1
MN1 n1 C n0 VSS sg13_lv_nmos w=4.5e-07 l=1.3e-07 ng=1
MN2 n2 B n1 VSS sg13_lv_nmos w=4.5e-07 l=1.3e-07 ng=1
MN3 Y A n2 VSS sg13_lv_nmos w=4.5e-07 l=1.3e-07 ng=1
MP0 Y A VDD VDD sg13_lv_pmos w=4e-07 l=1.3e-07 ng=1
MP1 Y B VDD VDD sg13_lv_pmos w=4e-07 l=1.3e-07 ng=1
MP2 Y C VDD VDD sg13_lv_pmos w=4e-07 l=1.3e-07 ng=1
MP3 Y D VDD VDD sg13_lv_pmos w=4e-07 l=1.3e-07 ng=1
.ENDS

****************************************
* Cell : NOR2_D1
* Description : Two input NOR gate
* Reduced truth table for output Y
* ┌─────┬─────┬─────┐
* │ A   │ B   │   Y │
* ├─────┼─────┼─────┤
* │ 0   │ 0   │   1 │
* ├─────┼─────┼─────┤
* │ 1   │ -   │   0 │
* ├─────┼─────┼─────┤
* │ -   │ 1   │   0 │
* └─────┴─────┴─────┘
****************************************
.SUBCKT NOR2_D1 A B Y VDD VSS
*.PININFO A:I B:I Y:O VDD:B VSS:B
MN0 Y A VSS VSS sg13_lv_nmos w=6.4e-07 l=1.3e-07 ng=1
MN1 Y B VSS VSS sg13_lv_nmos w=6.4e-07 l=1.3e-07 ng=1
MP0 n0 A VDD VDD sg13_lv_pmos w=9.8e-07 l=1.3e-07 ng=1
MP1 Y B n0 VDD sg13_lv_pmos w=9.8e-07 l=1.3e-07 ng=1
.ENDS

****************************************
* Cell : NOR2_D2
* Description : Two input NOR gate
* Reduced truth table for output Y
* ┌─────┬─────┬─────┐
* │ A   │ B   │   Y │
* ├─────┼─────┼─────┤
* │ 0   │ 0   │   1 │
* ├─────┼─────┼─────┤
* │ 1   │ -   │   0 │
* ├─────┼─────┼─────┤
* │ -   │ 1   │   0 │
* └─────┴─────┴─────┘
****************************************
.SUBCKT NOR2_D2 A B Y VDD VSS
*.PININFO A:I B:I Y:O VDD:B VSS:B
MN0 Y B VSS VSS sg13_lv_nmos w=1.07e-06 l=1.3e-07 ng=1
MN1 Y A VSS VSS sg13_lv_nmos w=1.07e-06 l=1.3e-07 ng=1
MP0 n0 A VDD VDD sg13_lv_pmos w=1.07e-06 l=1.3e-07 ng=1
MP1 Y B n0 VDD sg13_lv_pmos w=1.07e-06 l=1.3e-07 ng=1
MP2 n1 A VDD VDD sg13_lv_pmos w=1.07e-06 l=1.3e-07 ng=1
MP3 Y B n1 VDD sg13_lv_pmos w=1.07e-06 l=1.3e-07 ng=1
.ENDS

****************************************
* Cell : NOR2_D4
* Description : Two input NOR gate
* Reduced truth table for output Y
* ┌─────┬─────┬─────┐
* │ A   │ B   │   Y │
* ├─────┼─────┼─────┤
* │ 0   │ 0   │   1 │
* ├─────┼─────┼─────┤
* │ 1   │ -   │   0 │
* ├─────┼─────┼─────┤
* │ -   │ 1   │   0 │
* └─────┴─────┴─────┘
****************************************
.SUBCKT NOR2_D4 A B Y VDD VSS
*.PININFO A:I B:I Y:O VDD:B VSS:B
MN0 Y B VSS VSS sg13_lv_nmos w=2.14e-06 l=1.3e-07 ng=2
MN1 Y A VSS VSS sg13_lv_nmos w=2.14e-06 l=1.3e-07 ng=2
MP0 n0 A VDD VDD sg13_lv_pmos w=1.43e-06 l=1.3e-07 ng=1
MP1 Y B n0 VDD sg13_lv_pmos w=1.43e-06 l=1.3e-07 ng=1
MP2 n1 A VDD VDD sg13_lv_pmos w=1.43e-06 l=1.3e-07 ng=1
MP3 Y B n1 VDD sg13_lv_pmos w=1.43e-06 l=1.3e-07 ng=1
MP4 n2 A VDD VDD sg13_lv_pmos w=1.43e-06 l=1.3e-07 ng=1
MP5 Y B n2 VDD sg13_lv_pmos w=1.43e-06 l=1.3e-07 ng=1
.ENDS

****************************************
* Cell : NOR2_D8
* Description : Two input NOR gate
* Reduced truth table for output Y
* ┌─────┬─────┬─────┐
* │ A   │ B   │   Y │
* ├─────┼─────┼─────┤
* │ 0   │ 0   │   1 │
* ├─────┼─────┼─────┤
* │ 1   │ -   │   0 │
* ├─────┼─────┼─────┤
* │ -   │ 1   │   0 │
* └─────┴─────┴─────┘
****************************************
.SUBCKT NOR2_D8 A B Y VDD VSS
*.PININFO A:I B:I Y:O VDD:B VSS:B
MN0 Y B VSS VSS sg13_lv_nmos w=4.28e-06 l=1.3e-07 ng=4
MN1 Y A VSS VSS sg13_lv_nmos w=4.28e-06 l=1.3e-07 ng=4
MP0 n0 A VDD VDD sg13_lv_pmos w=1.43e-06 l=1.3e-07 ng=1
MP1 Y B n0 VDD sg13_lv_pmos w=1.43e-06 l=1.3e-07 ng=1
MP2 n1 A VDD VDD sg13_lv_pmos w=1.43e-06 l=1.3e-07 ng=1
MP3 Y B n1 VDD sg13_lv_pmos w=1.43e-06 l=1.3e-07 ng=1
MP4 n2 A VDD VDD sg13_lv_pmos w=1.43e-06 l=1.3e-07 ng=1
MP5 Y B n2 VDD sg13_lv_pmos w=1.43e-06 l=1.3e-07 ng=1
MP6 n3 A VDD VDD sg13_lv_pmos w=1.43e-06 l=1.3e-07 ng=1
MP7 Y B n3 VDD sg13_lv_pmos w=1.43e-06 l=1.3e-07 ng=1
MP8 n4 A VDD VDD sg13_lv_pmos w=1.43e-06 l=1.3e-07 ng=1
MP9 Y B n4 VDD sg13_lv_pmos w=1.43e-06 l=1.3e-07 ng=1
MP10 n5 A VDD VDD sg13_lv_pmos w=1.43e-06 l=1.3e-07 ng=1
MP11 Y B n5 VDD sg13_lv_pmos w=1.43e-06 l=1.3e-07 ng=1
.ENDS

****************************************
* Cell : NOR2_DL
* Description : Two input NOR gate
* Reduced truth table for output Y
* ┌─────┬─────┬─────┐
* │ A   │ B   │   Y │
* ├─────┼─────┼─────┤
* │ 0   │ 0   │   1 │
* ├─────┼─────┼─────┤
* │ 1   │ -   │   0 │
* ├─────┼─────┼─────┤
* │ -   │ 1   │   0 │
* └─────┴─────┴─────┘
****************************************
.SUBCKT NOR2_DL A B Y VDD VSS
*.PININFO A:I B:I Y:O VDD:B VSS:B
MN0 Y A VSS VSS sg13_lv_nmos w=3.2e-07 l=1.3e-07 ng=1
MN1 Y B VSS VSS sg13_lv_nmos w=3.2e-07 l=1.3e-07 ng=1
MP0 n0 A VDD VDD sg13_lv_pmos w=4.8e-07 l=1.3e-07 ng=1
MP1 Y B n0 VDD sg13_lv_pmos w=4.8e-07 l=1.3e-07 ng=1
.ENDS

****************************************
* Cell : NOR3_D1
* Description : Three input NOR gate
* Reduced truth table for output Y
* ┌─────┬─────┬─────┬─────┐
* │ A   │ B   │ C   │   Y │
* ├─────┼─────┼─────┼─────┤
* │ 0   │ 0   │ 0   │   1 │
* ├─────┼─────┼─────┼─────┤
* │ 1   │ -   │ -   │   0 │
* ├─────┼─────┼─────┼─────┤
* │ -   │ 1   │ -   │   0 │
* ├─────┼─────┼─────┼─────┤
* │ -   │ -   │ 1   │   0 │
* └─────┴─────┴─────┴─────┘
****************************************
.SUBCKT NOR3_D1 A B C Y VDD VSS
*.PININFO A:I B:I C:I Y:O VDD:B VSS:B
MN0 Y A VSS VSS sg13_lv_nmos w=5e-07 l=1.3e-07 ng=1
MN1 Y B VSS VSS sg13_lv_nmos w=5e-07 l=1.3e-07 ng=1
MN2 Y C VSS VSS sg13_lv_nmos w=5e-07 l=1.3e-07 ng=1
MP0 n0 A VDD VDD sg13_lv_pmos w=1.25e-06 l=1.3e-07 ng=1
MP1 n1 B n0 VDD sg13_lv_pmos w=1.25e-06 l=1.3e-07 ng=1
MP2 Y C n1 VDD sg13_lv_pmos w=1.25e-06 l=1.3e-07 ng=1
.ENDS

****************************************
* Cell : NOR3_D2
* Description : Three input NOR gate
* Reduced truth table for output Y
* ┌─────┬─────┬─────┬─────┐
* │ A   │ B   │ C   │   Y │
* ├─────┼─────┼─────┼─────┤
* │ 0   │ 0   │ 0   │   1 │
* ├─────┼─────┼─────┼─────┤
* │ 1   │ -   │ -   │   0 │
* ├─────┼─────┼─────┼─────┤
* │ -   │ 1   │ -   │   0 │
* ├─────┼─────┼─────┼─────┤
* │ -   │ -   │ 1   │   0 │
* └─────┴─────┴─────┴─────┘
****************************************
.SUBCKT NOR3_D2 A B C Y VDD VSS
*.PININFO A:I B:I C:I Y:O VDD:B VSS:B
MN0 Y A VSS VSS sg13_lv_nmos w=5e-07 l=1.3e-07 ng=1
MN1 Y B VSS VSS sg13_lv_nmos w=5e-07 l=1.3e-07 ng=1
MN2 Y C VSS VSS sg13_lv_nmos w=5e-07 l=1.3e-07 ng=1
MP0 n0 A VDD VDD sg13_lv_pmos w=1.25e-06 l=1.3e-07 ng=1
MP1 n1 B n0 VDD sg13_lv_pmos w=1.25e-06 l=1.3e-07 ng=1
MP2 Y C n1 VDD sg13_lv_pmos w=1.25e-06 l=1.3e-07 ng=1
MN3 Y A VSS VSS sg13_lv_nmos w=5e-07 l=1.3e-07 ng=1
MN4 Y B VSS VSS sg13_lv_nmos w=5e-07 l=1.3e-07 ng=1
MN5 Y C VSS VSS sg13_lv_nmos w=5e-07 l=1.3e-07 ng=1
MP3 n2 A VDD VDD sg13_lv_pmos w=1.25e-06 l=1.3e-07 ng=1
MP4 n3 B n2 VDD sg13_lv_pmos w=1.25e-06 l=1.3e-07 ng=1
MP5 Y C n3 VDD sg13_lv_pmos w=1.25e-06 l=1.3e-07 ng=1
.ENDS

****************************************
* Cell : NOR3_D4
* Description : Three input NOR gate
* Reduced truth table for output Y
* ┌─────┬─────┬─────┬─────┐
* │ A   │ B   │ C   │   Y │
* ├─────┼─────┼─────┼─────┤
* │ 0   │ 0   │ 0   │   1 │
* ├─────┼─────┼─────┼─────┤
* │ 1   │ -   │ -   │   0 │
* ├─────┼─────┼─────┼─────┤
* │ -   │ 1   │ -   │   0 │
* ├─────┼─────┼─────┼─────┤
* │ -   │ -   │ 1   │   0 │
* └─────┴─────┴─────┴─────┘
****************************************
.SUBCKT NOR3_D4 A B C Y VDD VSS
*.PININFO A:I B:I C:I Y:O VDD:B VSS:B
MN0 Y A VSS VSS sg13_lv_nmos w=5e-07 l=1.3e-07 ng=1
MN1 Y B VSS VSS sg13_lv_nmos w=5e-07 l=1.3e-07 ng=1
MN2 Y C VSS VSS sg13_lv_nmos w=5e-07 l=1.3e-07 ng=1
MP0 n0 A VDD VDD sg13_lv_pmos w=1.25e-06 l=1.3e-07 ng=1
MP1 n1 B n0 VDD sg13_lv_pmos w=1.25e-06 l=1.3e-07 ng=1
MP2 Y C n1 VDD sg13_lv_pmos w=1.25e-06 l=1.3e-07 ng=1
MN3 Y A VSS VSS sg13_lv_nmos w=5e-07 l=1.3e-07 ng=1
MN4 Y B VSS VSS sg13_lv_nmos w=5e-07 l=1.3e-07 ng=1
MN5 Y C VSS VSS sg13_lv_nmos w=5e-07 l=1.3e-07 ng=1
MP3 n2 A VDD VDD sg13_lv_pmos w=1.25e-06 l=1.3e-07 ng=1
MP4 n3 B n2 VDD sg13_lv_pmos w=1.25e-06 l=1.3e-07 ng=1
MP5 Y C n3 VDD sg13_lv_pmos w=1.25e-06 l=1.3e-07 ng=1
MN6 Y A VSS VSS sg13_lv_nmos w=5e-07 l=1.3e-07 ng=1
MN7 Y B VSS VSS sg13_lv_nmos w=5e-07 l=1.3e-07 ng=1
MN8 Y C VSS VSS sg13_lv_nmos w=5e-07 l=1.3e-07 ng=1
MP6 n4 A VDD VDD sg13_lv_pmos w=1.25e-06 l=1.3e-07 ng=1
MP7 n5 B n4 VDD sg13_lv_pmos w=1.25e-06 l=1.3e-07 ng=1
MP8 Y C n5 VDD sg13_lv_pmos w=1.25e-06 l=1.3e-07 ng=1
MN9 Y A VSS VSS sg13_lv_nmos w=5e-07 l=1.3e-07 ng=1
MN10 Y B VSS VSS sg13_lv_nmos w=5e-07 l=1.3e-07 ng=1
MN11 Y C VSS VSS sg13_lv_nmos w=5e-07 l=1.3e-07 ng=1
MP9 n6 A VDD VDD sg13_lv_pmos w=1.25e-06 l=1.3e-07 ng=1
MP10 n7 B n6 VDD sg13_lv_pmos w=1.25e-06 l=1.3e-07 ng=1
MP11 Y C n7 VDD sg13_lv_pmos w=1.25e-06 l=1.3e-07 ng=1
.ENDS

****************************************
* Cell : NOR3_DL
* Description : Three input NOR gate
* Reduced truth table for output Y
* ┌─────┬─────┬─────┬─────┐
* │ A   │ B   │ C   │   Y │
* ├─────┼─────┼─────┼─────┤
* │ 0   │ 0   │ 0   │   1 │
* ├─────┼─────┼─────┼─────┤
* │ 1   │ -   │ -   │   0 │
* ├─────┼─────┼─────┼─────┤
* │ -   │ 1   │ -   │   0 │
* ├─────┼─────┼─────┼─────┤
* │ -   │ -   │ 1   │   0 │
* └─────┴─────┴─────┴─────┘
****************************************
.SUBCKT NOR3_DL A B C Y VDD VSS
*.PININFO A:I B:I C:I Y:O VDD:B VSS:B
MN0 Y A VSS VSS sg13_lv_nmos w=3e-07 l=1.3e-07 ng=1
MN1 Y B VSS VSS sg13_lv_nmos w=3e-07 l=1.3e-07 ng=1
MN2 Y C VSS VSS sg13_lv_nmos w=3e-07 l=1.3e-07 ng=1
MP0 n0 A VDD VDD sg13_lv_pmos w=7.5e-07 l=1.3e-07 ng=1
MP1 n1 B n0 VDD sg13_lv_pmos w=7.5e-07 l=1.3e-07 ng=1
MP2 Y C n1 VDD sg13_lv_pmos w=7.5e-07 l=1.3e-07 ng=1
.ENDS

****************************************
* Cell : NOR4N1_D1
* Description : Four input NOR gate with one input inverted
* Reduced truth table for output Y
* ┌──────┬─────┬─────┬─────┬─────┐
* │ AN   │ B   │ C   │ D   │   Y │
* ├──────┼─────┼─────┼─────┼─────┤
* │ 1    │ 0   │ 0   │ 0   │   1 │
* ├──────┼─────┼─────┼─────┼─────┤
* │ 0    │ -   │ -   │ -   │   0 │
* ├──────┼─────┼─────┼─────┼─────┤
* │ -    │ 1   │ -   │ -   │   0 │
* ├──────┼─────┼─────┼─────┼─────┤
* │ -    │ -   │ 1   │ -   │   0 │
* ├──────┼─────┼─────┼─────┼─────┤
* │ -    │ -   │ -   │ 1   │   0 │
* └──────┴─────┴─────┴─────┴─────┘
****************************************
.SUBCKT NOR4N1_D1 AN B C D Y VDD VSS
*.PININFO AN:I B:I C:I D:I Y:O VDD:B VSS:B
MN0 n0 AN VSS VSS sg13_lv_nmos w=2e-07 l=1.3e-07 ng=1
MP0 n0 AN VDD VDD sg13_lv_pmos w=3e-07 l=1.3e-07 ng=1
MN1 Y n0 VSS VSS sg13_lv_nmos w=5e-07 l=1.3e-07 ng=1
MN2 Y B VSS VSS sg13_lv_nmos w=5e-07 l=1.3e-07 ng=1
MN3 Y C VSS VSS sg13_lv_nmos w=5e-07 l=1.3e-07 ng=1
MN4 Y D VSS VSS sg13_lv_nmos w=5e-07 l=1.3e-07 ng=1
MP1 n1 D VDD VDD sg13_lv_pmos w=1.4e-06 l=1.3e-07 ng=1
MP2 n2 C n1 VDD sg13_lv_pmos w=1.4e-06 l=1.3e-07 ng=1
MP3 n3 B n2 VDD sg13_lv_pmos w=1.4e-06 l=1.3e-07 ng=1
MP4 Y n0 n3 VDD sg13_lv_pmos w=1.4e-06 l=1.3e-07 ng=1
.ENDS

****************************************
* Cell : NOR4N1_D2
* Description : Four input NOR gate with one input inverted
* Reduced truth table for output Y
* ┌──────┬─────┬─────┬─────┬─────┐
* │ AN   │ B   │ C   │ D   │   Y │
* ├──────┼─────┼─────┼─────┼─────┤
* │ 1    │ 0   │ 0   │ 0   │   1 │
* ├──────┼─────┼─────┼─────┼─────┤
* │ 0    │ -   │ -   │ -   │   0 │
* ├──────┼─────┼─────┼─────┼─────┤
* │ -    │ 1   │ -   │ -   │   0 │
* ├──────┼─────┼─────┼─────┼─────┤
* │ -    │ -   │ 1   │ -   │   0 │
* ├──────┼─────┼─────┼─────┼─────┤
* │ -    │ -   │ -   │ 1   │   0 │
* └──────┴─────┴─────┴─────┴─────┘
****************************************
.SUBCKT NOR4N1_D2 AN B C D Y VDD VSS
*.PININFO AN:I B:I C:I D:I Y:O VDD:B VSS:B
MN0 n0 AN VSS VSS sg13_lv_nmos w=6e-07 l=1.3e-07 ng=1
MP0 n0 AN VDD VDD sg13_lv_pmos w=9e-07 l=1.3e-07 ng=1
MN1 Y n0 VSS VSS sg13_lv_nmos w=8e-07 l=1.3e-07 ng=1
MN2 Y B VSS VSS sg13_lv_nmos w=8e-07 l=1.3e-07 ng=1
MN3 Y C VSS VSS sg13_lv_nmos w=8e-07 l=1.3e-07 ng=1
MN4 Y D VSS VSS sg13_lv_nmos w=8e-07 l=1.3e-07 ng=1
MP1 n1 D VDD VDD sg13_lv_pmos w=2.2e-06 l=1.3e-07 ng=2
MP2 n2 C n1 VDD sg13_lv_pmos w=2.2e-06 l=1.3e-07 ng=2
MP3 n3 B n2 VDD sg13_lv_pmos w=2.2e-06 l=1.3e-07 ng=2
MP4 Y n0 n3 VDD sg13_lv_pmos w=2.2e-06 l=1.3e-07 ng=2
.ENDS

****************************************
* Cell : NOR4N1_D4
* Description : Four input NOR gate with one input inverted
* Reduced truth table for output Y
* ┌──────┬─────┬─────┬─────┬─────┐
* │ AN   │ B   │ C   │ D   │   Y │
* ├──────┼─────┼─────┼─────┼─────┤
* │ 1    │ 0   │ 0   │ 0   │   1 │
* ├──────┼─────┼─────┼─────┼─────┤
* │ 0    │ -   │ -   │ -   │   0 │
* ├──────┼─────┼─────┼─────┼─────┤
* │ -    │ 1   │ -   │ -   │   0 │
* ├──────┼─────┼─────┼─────┼─────┤
* │ -    │ -   │ 1   │ -   │   0 │
* ├──────┼─────┼─────┼─────┼─────┤
* │ -    │ -   │ -   │ 1   │   0 │
* └──────┴─────┴─────┴─────┴─────┘
****************************************
.SUBCKT NOR4N1_D4 AN B C D Y VDD VSS
*.PININFO AN:I B:I C:I D:I Y:O VDD:B VSS:B
MN0 n0 AN VSS VSS sg13_lv_nmos w=8.9e-07 l=1.3e-07 ng=1
MP0 n0 AN VDD VDD sg13_lv_pmos w=1.4e-06 l=1.3e-07 ng=1
MN1 Y n0 VSS VSS sg13_lv_nmos w=1.5e-06 l=1.3e-07 ng=2
MN2 Y B VSS VSS sg13_lv_nmos w=1.5e-06 l=1.3e-07 ng=2
MN3 Y C VSS VSS sg13_lv_nmos w=1.5e-06 l=1.3e-07 ng=2
MN4 Y D VSS VSS sg13_lv_nmos w=1.5e-06 l=1.3e-07 ng=2
MP1 n1 D VDD VDD sg13_lv_pmos w=4.41e-06 l=1.3e-07 ng=3
MP2 n2 C n1 VDD sg13_lv_pmos w=4.41e-06 l=1.3e-07 ng=3
MP3 n3 B n2 VDD sg13_lv_pmos w=4.41e-06 l=1.3e-07 ng=3
MP4 Y n0 n3 VDD sg13_lv_pmos w=4.41e-06 l=1.3e-07 ng=3
.ENDS

****************************************
* Cell : NOR4N1_DL
* Description : Four input NOR gate with one input inverted
* Reduced truth table for output Y
* ┌──────┬─────┬─────┬─────┬─────┐
* │ AN   │ B   │ C   │ D   │   Y │
* ├──────┼─────┼─────┼─────┼─────┤
* │ 1    │ 0   │ 0   │ 0   │   1 │
* ├──────┼─────┼─────┼─────┼─────┤
* │ 0    │ -   │ -   │ -   │   0 │
* ├──────┼─────┼─────┼─────┼─────┤
* │ -    │ 1   │ -   │ -   │   0 │
* ├──────┼─────┼─────┼─────┼─────┤
* │ -    │ -   │ 1   │ -   │   0 │
* ├──────┼─────┼─────┼─────┼─────┤
* │ -    │ -   │ -   │ 1   │   0 │
* └──────┴─────┴─────┴─────┴─────┘
****************************************
.SUBCKT NOR4N1_DL AN B C D Y VDD VSS
*.PININFO AN:I B:I C:I D:I Y:O VDD:B VSS:B
MN0 n0 AN VSS VSS sg13_lv_nmos w=1.5e-07 l=1.3e-07 ng=1
MP0 n0 AN VDD VDD sg13_lv_pmos w=2.3e-07 l=1.3e-07 ng=1
MN1 Y n0 VSS VSS sg13_lv_nmos w=2e-07 l=1.3e-07 ng=1
MN2 Y B VSS VSS sg13_lv_nmos w=2e-07 l=1.3e-07 ng=1
MN3 Y C VSS VSS sg13_lv_nmos w=2e-07 l=1.3e-07 ng=1
MN4 Y D VSS VSS sg13_lv_nmos w=2e-07 l=1.3e-07 ng=1
MP1 n1 D VDD VDD sg13_lv_pmos w=6e-07 l=1.3e-07 ng=1
MP2 n2 C n1 VDD sg13_lv_pmos w=6e-07 l=1.3e-07 ng=1
MP3 n3 B n2 VDD sg13_lv_pmos w=6e-07 l=1.3e-07 ng=1
MP4 Y n0 n3 VDD sg13_lv_pmos w=6e-07 l=1.3e-07 ng=1
.ENDS

****************************************
* Cell : NOR4N2_D1
* Description : Four input NOR gate with two inputs inverted
* Reduced truth table for output Y
* ┌──────┬──────┬─────┬─────┬─────┐
* │ AN   │ BN   │ C   │ D   │   Y │
* ├──────┼──────┼─────┼─────┼─────┤
* │ 1    │ 1    │ 0   │ 0   │   1 │
* ├──────┼──────┼─────┼─────┼─────┤
* │ 0    │ -    │ -   │ -   │   0 │
* ├──────┼──────┼─────┼─────┼─────┤
* │ -    │ 0    │ -   │ -   │   0 │
* ├──────┼──────┼─────┼─────┼─────┤
* │ -    │ -    │ 1   │ -   │   0 │
* ├──────┼──────┼─────┼─────┼─────┤
* │ -    │ -    │ -   │ 1   │   0 │
* └──────┴──────┴─────┴─────┴─────┘
****************************************
.SUBCKT NOR4N2_D1 AN BN C D Y VDD VSS
*.PININFO AN:I BN:I C:I D:I Y:O VDD:B VSS:B
MN0 n0 AN VSS VSS sg13_lv_nmos w=2.5e-07 l=1.3e-07 ng=1
MP0 n0 AN VDD VDD sg13_lv_pmos w=4e-07 l=1.3e-07 ng=1
MN1 n1 BN VSS VSS sg13_lv_nmos w=2.5e-07 l=1.3e-07 ng=1
MP1 n1 BN VDD VDD sg13_lv_pmos w=4e-07 l=1.3e-07 ng=1
MN2 Y n0 VSS VSS sg13_lv_nmos w=5e-07 l=1.3e-07 ng=1
MN3 Y n1 VSS VSS sg13_lv_nmos w=5e-07 l=1.3e-07 ng=1
MN4 Y C VSS VSS sg13_lv_nmos w=5e-07 l=1.3e-07 ng=1
MN5 Y D VSS VSS sg13_lv_nmos w=5e-07 l=1.3e-07 ng=1
MP2 n2 D VDD VDD sg13_lv_pmos w=1.4e-06 l=1.3e-07 ng=1
MP3 n3 C n2 VDD sg13_lv_pmos w=1.4e-06 l=1.3e-07 ng=1
MP4 n4 n1 n3 VDD sg13_lv_pmos w=1.4e-06 l=1.3e-07 ng=1
MP5 Y n0 n4 VDD sg13_lv_pmos w=1.4e-06 l=1.3e-07 ng=1
.ENDS

****************************************
* Cell : NOR4N2_D2
* Description : Four input NOR gate with two inputs inverted
* Reduced truth table for output Y
* ┌──────┬──────┬─────┬─────┬─────┐
* │ AN   │ BN   │ C   │ D   │   Y │
* ├──────┼──────┼─────┼─────┼─────┤
* │ 1    │ 1    │ 0   │ 0   │   1 │
* ├──────┼──────┼─────┼─────┼─────┤
* │ 0    │ -    │ -   │ -   │   0 │
* ├──────┼──────┼─────┼─────┼─────┤
* │ -    │ 0    │ -   │ -   │   0 │
* ├──────┼──────┼─────┼─────┼─────┤
* │ -    │ -    │ 1   │ -   │   0 │
* ├──────┼──────┼─────┼─────┼─────┤
* │ -    │ -    │ -   │ 1   │   0 │
* └──────┴──────┴─────┴─────┴─────┘
****************************************
.SUBCKT NOR4N2_D2 AN BN C D Y VDD VSS
*.PININFO AN:I BN:I C:I D:I Y:O VDD:B VSS:B
MN0 n0 AN VSS VSS sg13_lv_nmos w=5.3e-07 l=1.3e-07 ng=1
MP0 n0 AN VDD VDD sg13_lv_pmos w=8e-07 l=1.3e-07 ng=1
MN1 n1 BN VSS VSS sg13_lv_nmos w=5.3e-07 l=1.3e-07 ng=1
MP1 n1 BN VDD VDD sg13_lv_pmos w=8e-07 l=1.3e-07 ng=1
MN2 Y n0 VSS VSS sg13_lv_nmos w=8e-07 l=1.3e-07 ng=1
MN3 Y n1 VSS VSS sg13_lv_nmos w=8e-07 l=1.3e-07 ng=1
MN4 Y C VSS VSS sg13_lv_nmos w=8e-07 l=1.3e-07 ng=1
MN5 Y D VSS VSS sg13_lv_nmos w=8e-07 l=1.3e-07 ng=1
MP2 n2 D VDD VDD sg13_lv_pmos w=2.2e-06 l=1.3e-07 ng=2
MP3 n3 C n2 VDD sg13_lv_pmos w=2.2e-06 l=1.3e-07 ng=2
MP4 n4 n1 n3 VDD sg13_lv_pmos w=2.2e-06 l=1.3e-07 ng=2
MP5 Y n0 n4 VDD sg13_lv_pmos w=2.2e-06 l=1.3e-07 ng=2
.ENDS

****************************************
* Cell : NOR4N2_DL
* Description : Four input NOR gate with two inputs inverted
* Reduced truth table for output Y
* ┌──────┬──────┬─────┬─────┬─────┐
* │ AN   │ BN   │ C   │ D   │   Y │
* ├──────┼──────┼─────┼─────┼─────┤
* │ 1    │ 1    │ 0   │ 0   │   1 │
* ├──────┼──────┼─────┼─────┼─────┤
* │ 0    │ -    │ -   │ -   │   0 │
* ├──────┼──────┼─────┼─────┼─────┤
* │ -    │ 0    │ -   │ -   │   0 │
* ├──────┼──────┼─────┼─────┼─────┤
* │ -    │ -    │ 1   │ -   │   0 │
* ├──────┼──────┼─────┼─────┼─────┤
* │ -    │ -    │ -   │ 1   │   0 │
* └──────┴──────┴─────┴─────┴─────┘
****************************************
.SUBCKT NOR4N2_DL AN BN C D Y VDD VSS
*.PININFO AN:I BN:I C:I D:I Y:O VDD:B VSS:B
MN0 n0 AN VSS VSS sg13_lv_nmos w=1.5e-07 l=1.3e-07 ng=1
MP0 n0 AN VDD VDD sg13_lv_pmos w=2.3e-07 l=1.3e-07 ng=1
MN1 n1 BN VSS VSS sg13_lv_nmos w=1.5e-07 l=1.3e-07 ng=1
MP1 n1 BN VDD VDD sg13_lv_pmos w=2.3e-07 l=1.3e-07 ng=1
MN2 Y n0 VSS VSS sg13_lv_nmos w=3e-07 l=1.3e-07 ng=1
MN3 Y n1 VSS VSS sg13_lv_nmos w=3e-07 l=1.3e-07 ng=1
MN4 Y C VSS VSS sg13_lv_nmos w=3e-07 l=1.3e-07 ng=1
MN5 Y D VSS VSS sg13_lv_nmos w=3e-07 l=1.3e-07 ng=1
MP2 n2 D VDD VDD sg13_lv_pmos w=8e-07 l=1.3e-07 ng=1
MP3 n3 C n2 VDD sg13_lv_pmos w=8e-07 l=1.3e-07 ng=1
MP4 n4 n1 n3 VDD sg13_lv_pmos w=8e-07 l=1.3e-07 ng=1
MP5 Y n0 n4 VDD sg13_lv_pmos w=8e-07 l=1.3e-07 ng=1
.ENDS

****************************************
* Cell : NOR4_D1
* Description : Four input NOR gate
* Reduced truth table for output Y
* ┌─────┬─────┬─────┬─────┬─────┐
* │ A   │ B   │ C   │ D   │   Y │
* ├─────┼─────┼─────┼─────┼─────┤
* │ 0   │ 0   │ 0   │ 0   │   1 │
* ├─────┼─────┼─────┼─────┼─────┤
* │ 1   │ -   │ -   │ -   │   0 │
* ├─────┼─────┼─────┼─────┼─────┤
* │ -   │ 1   │ -   │ -   │   0 │
* ├─────┼─────┼─────┼─────┼─────┤
* │ -   │ -   │ 1   │ -   │   0 │
* ├─────┼─────┼─────┼─────┼─────┤
* │ -   │ -   │ -   │ 1   │   0 │
* └─────┴─────┴─────┴─────┴─────┘
****************************************
.SUBCKT NOR4_D1 A B C D Y VDD VSS
*.PININFO A:I B:I C:I D:I Y:O VDD:B VSS:B
MN0 Y A VSS VSS sg13_lv_nmos w=5e-07 l=1.3e-07 ng=1
MN1 Y B VSS VSS sg13_lv_nmos w=5e-07 l=1.3e-07 ng=1
MN2 Y C VSS VSS sg13_lv_nmos w=5e-07 l=1.3e-07 ng=1
MN3 Y D VSS VSS sg13_lv_nmos w=5e-07 l=1.3e-07 ng=1
MP0 n0 D VDD VDD sg13_lv_pmos w=1.4e-06 l=1.3e-07 ng=1
MP1 n1 C n0 VDD sg13_lv_pmos w=1.4e-06 l=1.3e-07 ng=1
MP2 n2 B n1 VDD sg13_lv_pmos w=1.4e-06 l=1.3e-07 ng=1
MP3 Y A n2 VDD sg13_lv_pmos w=1.4e-06 l=1.3e-07 ng=1
.ENDS

****************************************
* Cell : NOR4_D2
* Description : Four input NOR gate
* Reduced truth table for output Y
* ┌─────┬─────┬─────┬─────┬─────┐
* │ A   │ B   │ C   │ D   │   Y │
* ├─────┼─────┼─────┼─────┼─────┤
* │ 0   │ 0   │ 0   │ 0   │   1 │
* ├─────┼─────┼─────┼─────┼─────┤
* │ 1   │ -   │ -   │ -   │   0 │
* ├─────┼─────┼─────┼─────┼─────┤
* │ -   │ 1   │ -   │ -   │   0 │
* ├─────┼─────┼─────┼─────┼─────┤
* │ -   │ -   │ 1   │ -   │   0 │
* ├─────┼─────┼─────┼─────┼─────┤
* │ -   │ -   │ -   │ 1   │   0 │
* └─────┴─────┴─────┴─────┴─────┘
****************************************
.SUBCKT NOR4_D2 A B C D Y VDD VSS
*.PININFO A:I B:I C:I D:I Y:O VDD:B VSS:B
MN0 Y A VSS VSS sg13_lv_nmos w=8e-07 l=1.3e-07 ng=1
MN1 Y B VSS VSS sg13_lv_nmos w=8e-07 l=1.3e-07 ng=1
MN2 Y C VSS VSS sg13_lv_nmos w=8e-07 l=1.3e-07 ng=1
MN3 Y D VSS VSS sg13_lv_nmos w=8e-07 l=1.3e-07 ng=1
MP0 n0 D VDD VDD sg13_lv_pmos w=2.2e-06 l=1.3e-07 ng=2
MP1 n1 C n0 VDD sg13_lv_pmos w=2.2e-06 l=1.3e-07 ng=2
MP2 n2 B n1 VDD sg13_lv_pmos w=2.2e-06 l=1.3e-07 ng=2
MP3 Y A n2 VDD sg13_lv_pmos w=2.2e-06 l=1.3e-07 ng=2
.ENDS

****************************************
* Cell : NOR4_D4
* Description : Four input NOR gate
* Reduced truth table for output Y
* ┌─────┬─────┬─────┬─────┬─────┐
* │ A   │ B   │ C   │ D   │   Y │
* ├─────┼─────┼─────┼─────┼─────┤
* │ 0   │ 0   │ 0   │ 0   │   1 │
* ├─────┼─────┼─────┼─────┼─────┤
* │ 1   │ -   │ -   │ -   │   0 │
* ├─────┼─────┼─────┼─────┼─────┤
* │ -   │ 1   │ -   │ -   │   0 │
* ├─────┼─────┼─────┼─────┼─────┤
* │ -   │ -   │ 1   │ -   │   0 │
* ├─────┼─────┼─────┼─────┼─────┤
* │ -   │ -   │ -   │ 1   │   0 │
* └─────┴─────┴─────┴─────┴─────┘
****************************************
.SUBCKT NOR4_D4 A B C D Y VDD VSS
*.PININFO A:I B:I C:I D:I Y:O VDD:B VSS:B
MN0 Y A VSS VSS sg13_lv_nmos w=1.5e-06 l=1.3e-07 ng=2
MN1 Y B VSS VSS sg13_lv_nmos w=1.5e-06 l=1.3e-07 ng=2
MN2 Y C VSS VSS sg13_lv_nmos w=1.5e-06 l=1.3e-07 ng=2
MN3 Y D VSS VSS sg13_lv_nmos w=1.5e-06 l=1.3e-07 ng=2
MP0 n0 D VDD VDD sg13_lv_pmos w=4.41e-06 l=1.3e-07 ng=3
MP1 n1 C n0 VDD sg13_lv_pmos w=4.41e-06 l=1.3e-07 ng=3
MP2 n2 B n1 VDD sg13_lv_pmos w=4.41e-06 l=1.3e-07 ng=3
MP3 Y A n2 VDD sg13_lv_pmos w=4.41e-06 l=1.3e-07 ng=3
.ENDS

****************************************
* Cell : NOR4_DL
* Description : Four input NOR gate
* Reduced truth table for output Y
* ┌─────┬─────┬─────┬─────┬─────┐
* │ A   │ B   │ C   │ D   │   Y │
* ├─────┼─────┼─────┼─────┼─────┤
* │ 0   │ 0   │ 0   │ 0   │   1 │
* ├─────┼─────┼─────┼─────┼─────┤
* │ 1   │ -   │ -   │ -   │   0 │
* ├─────┼─────┼─────┼─────┼─────┤
* │ -   │ 1   │ -   │ -   │   0 │
* ├─────┼─────┼─────┼─────┼─────┤
* │ -   │ -   │ 1   │ -   │   0 │
* ├─────┼─────┼─────┼─────┼─────┤
* │ -   │ -   │ -   │ 1   │   0 │
* └─────┴─────┴─────┴─────┴─────┘
****************************************
.SUBCKT NOR4_DL A B C D Y VDD VSS
*.PININFO A:I B:I C:I D:I Y:O VDD:B VSS:B
MN0 Y A VSS VSS sg13_lv_nmos w=3e-07 l=1.3e-07 ng=1
MN1 Y B VSS VSS sg13_lv_nmos w=3e-07 l=1.3e-07 ng=1
MN2 Y C VSS VSS sg13_lv_nmos w=3e-07 l=1.3e-07 ng=1
MN3 Y D VSS VSS sg13_lv_nmos w=3e-07 l=1.3e-07 ng=1
MP0 n0 D VDD VDD sg13_lv_pmos w=8.4e-07 l=1.3e-07 ng=1
MP1 n1 C n0 VDD sg13_lv_pmos w=8.4e-07 l=1.3e-07 ng=1
MP2 n2 B n1 VDD sg13_lv_pmos w=8.4e-07 l=1.3e-07 ng=1
MP3 Y A n2 VDD sg13_lv_pmos w=8.4e-07 l=1.3e-07 ng=1
.ENDS

****************************************
* Cell : OA21_D1
* Description : OR-AND gate with two OR inputs and one direct AND input
* Reduced truth table for output Y
* ┌─────┬─────┬─────┬─────┐
* │ A   │ B   │ C   │   Y │
* ├─────┼─────┼─────┼─────┤
* │ 1   │ -   │ 1   │   1 │
* ├─────┼─────┼─────┼─────┤
* │ -   │ 1   │ 1   │   1 │
* ├─────┼─────┼─────┼─────┤
* │ -   │ -   │ 0   │   0 │
* ├─────┼─────┼─────┼─────┤
* │ 0   │ 0   │ -   │   0 │
* └─────┴─────┴─────┴─────┘
****************************************
.SUBCKT OA21_D1 A B C Y VDD VSS
*.PININFO A:I B:I C:I Y:O VDD:B VSS:B
MN0 n0 A VSS VSS sg13_lv_nmos w=3e-07 l=1.3e-07
MN1 n0 B VSS VSS sg13_lv_nmos w=3e-07 l=1.3e-07
MN2 n0 C n1 VSS sg13_lv_nmos w=3e-07 l=1.3e-07
MP0 n1 C VDD VDD sg13_lv_pmos w=3.5e-07 l=1.3e-07
MP1 n2 A VDD VDD sg13_lv_pmos w=4.5e-07 l=1.3e-07
MP2 n2 B n1 VDD sg13_lv_pmos w=4.5e-07 l=1.3e-07
MN3 Y n1 VSS VSS sg13_lv_nmos w=6.4e-07 l=1.3e-07 ng=1
MP3 Y n1 VDD VDD sg13_lv_pmos w=9.8e-07 l=1.3e-07 ng=1
.ENDS

****************************************
* Cell : OA21_D2
* Description : OR-AND gate with two OR inputs and one direct AND input
* Reduced truth table for output Y
* ┌─────┬─────┬─────┬─────┐
* │ A   │ B   │ C   │   Y │
* ├─────┼─────┼─────┼─────┤
* │ 1   │ -   │ 1   │   1 │
* ├─────┼─────┼─────┼─────┤
* │ -   │ 1   │ 1   │   1 │
* ├─────┼─────┼─────┼─────┤
* │ -   │ -   │ 0   │   0 │
* ├─────┼─────┼─────┼─────┤
* │ 0   │ 0   │ -   │   0 │
* └─────┴─────┴─────┴─────┘
****************************************
.SUBCKT OA21_D2 A B C Y VDD VSS
*.PININFO A:I B:I C:I Y:O VDD:B VSS:B
MN0 n0 A VSS VSS sg13_lv_nmos w=5.5e-07 l=1.3e-07
MN1 n0 B VSS VSS sg13_lv_nmos w=5.5e-07 l=1.3e-07
MN2 n0 C n1 VSS sg13_lv_nmos w=5.5e-07 l=1.3e-07
MP0 n1 C VDD VDD sg13_lv_pmos w=6.5e-07 l=1.3e-07
MP1 n2 A VDD VDD sg13_lv_pmos w=8e-07 l=1.3e-07
MP2 n2 B n1 VDD sg13_lv_pmos w=8e-07 l=1.3e-07
MN3 Y n1 VSS VSS sg13_lv_nmos w=1.07e-06 l=1.3e-07 ng=1
MP3 Y n1 VDD VDD sg13_lv_pmos w=1.6e-06 l=1.3e-07 ng=1
.ENDS

****************************************
* Cell : OA21_D4
* Description : OR-AND gate with two OR inputs and one direct AND input
* Reduced truth table for output Y
* ┌─────┬─────┬─────┬─────┐
* │ A   │ B   │ C   │   Y │
* ├─────┼─────┼─────┼─────┤
* │ 1   │ -   │ 1   │   1 │
* ├─────┼─────┼─────┼─────┤
* │ -   │ 1   │ 1   │   1 │
* ├─────┼─────┼─────┼─────┤
* │ -   │ -   │ 0   │   0 │
* ├─────┼─────┼─────┼─────┤
* │ 0   │ 0   │ -   │   0 │
* └─────┴─────┴─────┴─────┘
****************************************
.SUBCKT OA21_D4 A B C Y VDD VSS
*.PININFO A:I B:I C:I Y:O VDD:B VSS:B
MN0 n0 A VSS VSS sg13_lv_nmos w=1e-06 l=1.3e-07
MN1 n0 B VSS VSS sg13_lv_nmos w=1e-06 l=1.3e-07
MN2 n0 C n1 VSS sg13_lv_nmos w=1e-06 l=1.3e-07
MP0 n1 C VDD VDD sg13_lv_pmos w=1.1e-06 l=1.3e-07
MP1 n2 A VDD VDD sg13_lv_pmos w=1.5e-06 l=1.3e-07
MP2 n2 B n1 VDD sg13_lv_pmos w=1.5e-06 l=1.3e-07
MN3 Y n1 VSS VSS sg13_lv_nmos w=2.14e-06 l=1.3e-07 ng=2
MP3 Y n1 VDD VDD sg13_lv_pmos w=3.2e-06 l=1.3e-07 ng=1
.ENDS

****************************************
* Cell : OA21_DL
* Description : OR-AND gate with two OR inputs and one direct AND input
* Reduced truth table for output Y
* ┌─────┬─────┬─────┬─────┐
* │ A   │ B   │ C   │   Y │
* ├─────┼─────┼─────┼─────┤
* │ 1   │ -   │ 1   │   1 │
* ├─────┼─────┼─────┼─────┤
* │ -   │ 1   │ 1   │   1 │
* ├─────┼─────┼─────┼─────┤
* │ -   │ -   │ 0   │   0 │
* ├─────┼─────┼─────┼─────┤
* │ 0   │ 0   │ -   │   0 │
* └─────┴─────┴─────┴─────┘
****************************************
.SUBCKT OA21_DL A B C Y VDD VSS
*.PININFO A:I B:I C:I Y:O VDD:B VSS:B
MN0 n0 A VSS VSS sg13_lv_nmos w=2e-07 l=1.3e-07
MN1 n0 B VSS VSS sg13_lv_nmos w=2e-07 l=1.3e-07
MN2 n0 C n1 VSS sg13_lv_nmos w=2e-07 l=1.3e-07
MP0 n1 C VDD VDD sg13_lv_pmos w=2.5e-07 l=1.3e-07
MP1 n2 A VDD VDD sg13_lv_pmos w=3e-07 l=1.3e-07
MP2 n2 B n1 VDD sg13_lv_pmos w=3e-07 l=1.3e-07
MN3 Y n1 VSS VSS sg13_lv_nmos w=3.2e-07 l=1.3e-07 ng=1
MP3 Y n1 VDD VDD sg13_lv_pmos w=4.9e-07 l=1.3e-07 ng=1
.ENDS

****************************************
* Cell : OA22_D1
* Description : OR-AND gate with two two-input OR gates
* Reduced truth table for output Y
* ┌─────┬─────┬─────┬─────┬─────┐
* │ A   │ B   │ C   │ D   │   Y │
* ├─────┼─────┼─────┼─────┼─────┤
* │ 1   │ -   │ 1   │ -   │   1 │
* ├─────┼─────┼─────┼─────┼─────┤
* │ 1   │ -   │ -   │ 1   │   1 │
* ├─────┼─────┼─────┼─────┼─────┤
* │ -   │ 1   │ 1   │ -   │   1 │
* ├─────┼─────┼─────┼─────┼─────┤
* │ -   │ 1   │ -   │ 1   │   1 │
* ├─────┼─────┼─────┼─────┼─────┤
* │ 0   │ 0   │ -   │ -   │   0 │
* ├─────┼─────┼─────┼─────┼─────┤
* │ -   │ -   │ 0   │ 0   │   0 │
* └─────┴─────┴─────┴─────┴─────┘
****************************************
.SUBCKT OA22_D1 A B C D Y VDD VSS
*.PININFO A:I B:I C:I D:I Y:O VDD:B VSS:B
MN0 n0 C VSS VSS sg13_lv_nmos w=3.5e-07 l=1.3e-07
MN1 n0 D VSS VSS sg13_lv_nmos w=3.5e-07 l=1.3e-07
MN2 n0 A n1 VSS sg13_lv_nmos w=3.5e-07 l=1.3e-07
MN3 n0 B n1 VSS sg13_lv_nmos w=3.5e-07 l=1.3e-07
MP0 n2 A VDD VDD sg13_lv_pmos w=5e-07 l=1.3e-07
MP1 n2 B n1 VDD sg13_lv_pmos w=5e-07 l=1.3e-07
MP2 n3 C VDD VDD sg13_lv_pmos w=5e-07 l=1.3e-07
MP3 n3 D n1 VDD sg13_lv_pmos w=5e-07 l=1.3e-07
MN4 Y n1 VSS VSS sg13_lv_nmos w=5e-07 l=1.3e-07 ng=1
MP4 Y n1 VDD VDD sg13_lv_pmos w=9.8e-07 l=1.3e-07 ng=1
.ENDS

****************************************
* Cell : OA22_D2
* Description : OR-AND gate with two two-input OR gates
* Reduced truth table for output Y
* ┌─────┬─────┬─────┬─────┬─────┐
* │ A   │ B   │ C   │ D   │   Y │
* ├─────┼─────┼─────┼─────┼─────┤
* │ 1   │ -   │ 1   │ -   │   1 │
* ├─────┼─────┼─────┼─────┼─────┤
* │ 1   │ -   │ -   │ 1   │   1 │
* ├─────┼─────┼─────┼─────┼─────┤
* │ -   │ 1   │ 1   │ -   │   1 │
* ├─────┼─────┼─────┼─────┼─────┤
* │ -   │ 1   │ -   │ 1   │   1 │
* ├─────┼─────┼─────┼─────┼─────┤
* │ 0   │ 0   │ -   │ -   │   0 │
* ├─────┼─────┼─────┼─────┼─────┤
* │ -   │ -   │ 0   │ 0   │   0 │
* └─────┴─────┴─────┴─────┴─────┘
****************************************
.SUBCKT OA22_D2 A B C D Y VDD VSS
*.PININFO A:I B:I C:I D:I Y:O VDD:B VSS:B
MN0 n0 C VSS VSS sg13_lv_nmos w=6e-07 l=1.3e-07
MN1 n0 D VSS VSS sg13_lv_nmos w=6e-07 l=1.3e-07
MN2 n0 A n1 VSS sg13_lv_nmos w=6e-07 l=1.3e-07
MN3 n0 B n1 VSS sg13_lv_nmos w=6e-07 l=1.3e-07
MP0 n2 A VDD VDD sg13_lv_pmos w=8e-07 l=1.3e-07
MP1 n2 B n1 VDD sg13_lv_pmos w=8e-07 l=1.3e-07
MP2 n3 C VDD VDD sg13_lv_pmos w=8e-07 l=1.3e-07
MP3 n3 D n1 VDD sg13_lv_pmos w=8e-07 l=1.3e-07
MN4 Y n1 VSS VSS sg13_lv_nmos w=1.07e-06 l=1.3e-07 ng=1
MP4 Y n1 VDD VDD sg13_lv_pmos w=1.6e-06 l=1.3e-07 ng=1
.ENDS

****************************************
* Cell : OA22_DL
* Description : OR-AND gate with two two-input OR gates
* Reduced truth table for output Y
* ┌─────┬─────┬─────┬─────┬─────┐
* │ A   │ B   │ C   │ D   │   Y │
* ├─────┼─────┼─────┼─────┼─────┤
* │ 1   │ -   │ 1   │ -   │   1 │
* ├─────┼─────┼─────┼─────┼─────┤
* │ 1   │ -   │ -   │ 1   │   1 │
* ├─────┼─────┼─────┼─────┼─────┤
* │ -   │ 1   │ 1   │ -   │   1 │
* ├─────┼─────┼─────┼─────┼─────┤
* │ -   │ 1   │ -   │ 1   │   1 │
* ├─────┼─────┼─────┼─────┼─────┤
* │ 0   │ 0   │ -   │ -   │   0 │
* ├─────┼─────┼─────┼─────┼─────┤
* │ -   │ -   │ 0   │ 0   │   0 │
* └─────┴─────┴─────┴─────┴─────┘
****************************************
.SUBCKT OA22_DL A B C D Y VDD VSS
*.PININFO A:I B:I C:I D:I Y:O VDD:B VSS:B
MN0 n0 C VSS VSS sg13_lv_nmos w=2.5e-07 l=1.3e-07
MN1 n0 D VSS VSS sg13_lv_nmos w=2.5e-07 l=1.3e-07
MN2 n0 A n1 VSS sg13_lv_nmos w=2.5e-07 l=1.3e-07
MN3 n0 B n1 VSS sg13_lv_nmos w=2.5e-07 l=1.3e-07
MP0 n2 A VDD VDD sg13_lv_pmos w=4e-07 l=1.3e-07
MP1 n2 B n1 VDD sg13_lv_pmos w=4e-07 l=1.3e-07
MP2 n3 C VDD VDD sg13_lv_pmos w=4e-07 l=1.3e-07
MP3 n3 D n1 VDD sg13_lv_pmos w=4e-07 l=1.3e-07
MN4 Y n1 VSS VSS sg13_lv_nmos w=4e-07 l=1.3e-07 ng=1
MP4 Y n1 VDD VDD sg13_lv_pmos w=6e-07 l=1.3e-07 ng=1
.ENDS

****************************************
* Cell : OAI211_D1
* Description : Inverted output OR-AND gate with two input OR gate and two direct inputs to AND gate
* Reduced truth table for output Y
* ┌─────┬─────┬─────┬─────┬─────┐
* │ A   │ B   │ C   │ D   │   Y │
* ├─────┼─────┼─────┼─────┼─────┤
* │ -   │ -   │ 0   │ -   │   1 │
* ├─────┼─────┼─────┼─────┼─────┤
* │ -   │ -   │ -   │ 0   │   1 │
* ├─────┼─────┼─────┼─────┼─────┤
* │ 0   │ 0   │ -   │ -   │   1 │
* ├─────┼─────┼─────┼─────┼─────┤
* │ 1   │ -   │ 1   │ 1   │   0 │
* ├─────┼─────┼─────┼─────┼─────┤
* │ -   │ 1   │ 1   │ 1   │   0 │
* └─────┴─────┴─────┴─────┴─────┘
****************************************
.SUBCKT OAI211_D1 A B C D Y VDD VSS
*.PININFO A:I B:I C:I D:I Y:O VDD:B VSS:B
MN0 n0 A VSS VSS sg13_lv_nmos w=9e-07 l=1.3e-07
MN1 n0 B VSS VSS sg13_lv_nmos w=9e-07 l=1.3e-07
MN2 n0 D n1 VSS sg13_lv_nmos w=9e-07 l=1.3e-07
MN3 n1 C Y VSS sg13_lv_nmos w=9e-07 l=1.3e-07
MP0 Y C VDD VDD sg13_lv_pmos w=9.8e-07 l=1.3e-07
MP1 Y D VDD VDD sg13_lv_pmos w=9.8e-07 l=1.3e-07
MP2 n2 A VDD VDD sg13_lv_pmos w=1.27e-06 l=1.3e-07
MP3 n2 B Y VDD sg13_lv_pmos w=1.27e-06 l=1.3e-07
.ENDS

****************************************
* Cell : OAI211_DL
* Description : Inverted output OR-AND gate with two input OR gate and two direct inputs to AND gate
* Reduced truth table for output Y
* ┌─────┬─────┬─────┬─────┬─────┐
* │ A   │ B   │ C   │ D   │   Y │
* ├─────┼─────┼─────┼─────┼─────┤
* │ -   │ -   │ 0   │ -   │   1 │
* ├─────┼─────┼─────┼─────┼─────┤
* │ -   │ -   │ -   │ 0   │   1 │
* ├─────┼─────┼─────┼─────┼─────┤
* │ 0   │ 0   │ -   │ -   │   1 │
* ├─────┼─────┼─────┼─────┼─────┤
* │ 1   │ -   │ 1   │ 1   │   0 │
* ├─────┼─────┼─────┼─────┼─────┤
* │ -   │ 1   │ 1   │ 1   │   0 │
* └─────┴─────┴─────┴─────┴─────┘
****************************************
.SUBCKT OAI211_DL A B C D Y VDD VSS
*.PININFO A:I B:I C:I D:I Y:O VDD:B VSS:B
MN0 n0 A VSS VSS sg13_lv_nmos w=6e-07 l=1.3e-07
MN1 n0 B VSS VSS sg13_lv_nmos w=6e-07 l=1.3e-07
MN2 n0 D n1 VSS sg13_lv_nmos w=6e-07 l=1.3e-07
MN3 n1 C Y VSS sg13_lv_nmos w=6e-07 l=1.3e-07
MP0 Y C VDD VDD sg13_lv_pmos w=6.5e-07 l=1.3e-07
MP1 Y D VDD VDD sg13_lv_pmos w=6.5e-07 l=1.3e-07
MP2 n2 A VDD VDD sg13_lv_pmos w=8.4e-07 l=1.3e-07
MP3 n2 B Y VDD sg13_lv_pmos w=8.4e-07 l=1.3e-07
.ENDS

****************************************
* Cell : OAI221_D1
* Description : Inverted output AND-OR gate with two two-input OR gates and one direct input to AND gate
* Reduced truth table for output Y
* ┌─────┬─────┬─────┬─────┬─────┬─────┐
* │ A   │ B   │ C   │ D   │ E   │   Y │
* ├─────┼─────┼─────┼─────┼─────┼─────┤
* │ -   │ -   │ -   │ -   │ 0   │   1 │
* ├─────┼─────┼─────┼─────┼─────┼─────┤
* │ 0   │ 0   │ -   │ -   │ -   │   1 │
* ├─────┼─────┼─────┼─────┼─────┼─────┤
* │ -   │ -   │ 0   │ 0   │ -   │   1 │
* ├─────┼─────┼─────┼─────┼─────┼─────┤
* │ 1   │ -   │ 1   │ -   │ 1   │   0 │
* ├─────┼─────┼─────┼─────┼─────┼─────┤
* │ 1   │ -   │ -   │ 1   │ 1   │   0 │
* ├─────┼─────┼─────┼─────┼─────┼─────┤
* │ -   │ 1   │ 1   │ -   │ 1   │   0 │
* ├─────┼─────┼─────┼─────┼─────┼─────┤
* │ -   │ 1   │ -   │ 1   │ 1   │   0 │
* └─────┴─────┴─────┴─────┴─────┴─────┘
****************************************
.SUBCKT OAI221_D1 A B C D E Y VDD VSS
*.PININFO A:I B:I C:I D:I E:I Y:O VDD:B VSS:B
MN0 n0 E Y VSS sg13_lv_nmos w=1e-06 l=1.3e-07
MN1 n1 A n0 VSS sg13_lv_nmos w=1e-06 l=1.3e-07
MN2 n1 B n0 VSS sg13_lv_nmos w=1e-06 l=1.3e-07
MN3 n1 D VSS VSS sg13_lv_nmos w=1e-06 l=1.3e-07
MN4 n1 C VSS VSS sg13_lv_nmos w=1e-06 l=1.3e-07
MP0 Y E VDD VDD sg13_lv_pmos w=1e-06 l=1.3e-07
MP1 n2 D VDD VDD sg13_lv_pmos w=1.27e-06 l=1.3e-07
MP2 Y C n2 VDD sg13_lv_pmos w=1.27e-06 l=1.3e-07
MP3 n3 B VDD VDD sg13_lv_pmos w=1.27e-06 l=1.3e-07
MP4 n3 A Y VDD sg13_lv_pmos w=1.27e-06 l=1.3e-07
.ENDS

****************************************
* Cell : OAI221_DL
* Description : Inverted output AND-OR gate with two two-input OR gates and one direct input to AND gate
* Reduced truth table for output Y
* ┌─────┬─────┬─────┬─────┬─────┬─────┐
* │ A   │ B   │ C   │ D   │ E   │   Y │
* ├─────┼─────┼─────┼─────┼─────┼─────┤
* │ -   │ -   │ -   │ -   │ 0   │   1 │
* ├─────┼─────┼─────┼─────┼─────┼─────┤
* │ 0   │ 0   │ -   │ -   │ -   │   1 │
* ├─────┼─────┼─────┼─────┼─────┼─────┤
* │ -   │ -   │ 0   │ 0   │ -   │   1 │
* ├─────┼─────┼─────┼─────┼─────┼─────┤
* │ 1   │ -   │ 1   │ -   │ 1   │   0 │
* ├─────┼─────┼─────┼─────┼─────┼─────┤
* │ 1   │ -   │ -   │ 1   │ 1   │   0 │
* ├─────┼─────┼─────┼─────┼─────┼─────┤
* │ -   │ 1   │ 1   │ -   │ 1   │   0 │
* ├─────┼─────┼─────┼─────┼─────┼─────┤
* │ -   │ 1   │ -   │ 1   │ 1   │   0 │
* └─────┴─────┴─────┴─────┴─────┴─────┘
****************************************
.SUBCKT OAI221_DL A B C D E Y VDD VSS
*.PININFO A:I B:I C:I D:I E:I Y:O VDD:B VSS:B
MN0 n0 E Y VSS sg13_lv_nmos w=6e-07 l=1.3e-07
MN1 n1 A n0 VSS sg13_lv_nmos w=6e-07 l=1.3e-07
MN2 n1 B n0 VSS sg13_lv_nmos w=6e-07 l=1.3e-07
MN3 n1 D VSS VSS sg13_lv_nmos w=6e-07 l=1.3e-07
MN4 n1 C VSS VSS sg13_lv_nmos w=6e-07 l=1.3e-07
MP0 Y E VDD VDD sg13_lv_pmos w=6e-07 l=1.3e-07
MP1 n2 D VDD VDD sg13_lv_pmos w=8e-07 l=1.3e-07
MP2 Y C n2 VDD sg13_lv_pmos w=8e-07 l=1.3e-07
MP3 n3 B VDD VDD sg13_lv_pmos w=8e-07 l=1.3e-07
MP4 n3 A Y VDD sg13_lv_pmos w=8e-07 l=1.3e-07
.ENDS

****************************************
* Cell : OAI222_D1
* Description : Inverted output OR-AND gate with three two-input OR gates
* Reduced truth table for output Y
* ┌─────┬─────┬─────┬─────┬─────┬─────┬─────┐
* │ A   │ B   │ C   │ D   │ E   │ F   │   Y │
* ├─────┼─────┼─────┼─────┼─────┼─────┼─────┤
* │ 0   │ 0   │ -   │ -   │ -   │ -   │   1 │
* ├─────┼─────┼─────┼─────┼─────┼─────┼─────┤
* │ -   │ -   │ 0   │ 0   │ -   │ -   │   1 │
* ├─────┼─────┼─────┼─────┼─────┼─────┼─────┤
* │ -   │ -   │ -   │ -   │ 0   │ 0   │   1 │
* ├─────┼─────┼─────┼─────┼─────┼─────┼─────┤
* │ 1   │ -   │ 1   │ -   │ 1   │ -   │   0 │
* ├─────┼─────┼─────┼─────┼─────┼─────┼─────┤
* │ 1   │ -   │ 1   │ -   │ -   │ 1   │   0 │
* ├─────┼─────┼─────┼─────┼─────┼─────┼─────┤
* │ 1   │ -   │ -   │ 1   │ 1   │ -   │   0 │
* ├─────┼─────┼─────┼─────┼─────┼─────┼─────┤
* │ 1   │ -   │ -   │ 1   │ -   │ 1   │   0 │
* ├─────┼─────┼─────┼─────┼─────┼─────┼─────┤
* │ -   │ 1   │ 1   │ -   │ 1   │ -   │   0 │
* ├─────┼─────┼─────┼─────┼─────┼─────┼─────┤
* │ -   │ 1   │ 1   │ -   │ -   │ 1   │   0 │
* ├─────┼─────┼─────┼─────┼─────┼─────┼─────┤
* │ -   │ 1   │ -   │ 1   │ 1   │ -   │   0 │
* ├─────┼─────┼─────┼─────┼─────┼─────┼─────┤
* │ -   │ 1   │ -   │ 1   │ -   │ 1   │   0 │
* └─────┴─────┴─────┴─────┴─────┴─────┴─────┘
****************************************
.SUBCKT OAI222_D1 A B C D E F Y VDD VSS
*.PININFO A:I B:I C:I D:I E:I F:I Y:O VDD:B VSS:B
MN0 n0 F Y VSS sg13_lv_nmos w=1e-06 l=1.3e-07
MN1 n0 E Y VSS sg13_lv_nmos w=1e-06 l=1.3e-07
MN2 n1 A n0 VSS sg13_lv_nmos w=1e-06 l=1.3e-07
MN3 n1 B n0 VSS sg13_lv_nmos w=1e-06 l=1.3e-07
MN4 n1 D VSS VSS sg13_lv_nmos w=1e-06 l=1.3e-07
MN5 n1 C VSS VSS sg13_lv_nmos w=1e-06 l=1.3e-07
MP0 n2 F VDD VDD sg13_lv_pmos w=1.27e-06 l=1.3e-07
MP1 Y E n2 VDD sg13_lv_pmos w=1.27e-06 l=1.3e-07
MP2 n3 D VDD VDD sg13_lv_pmos w=1.27e-06 l=1.3e-07
MP3 Y C n3 VDD sg13_lv_pmos w=1.27e-06 l=1.3e-07
MP4 n4 B VDD VDD sg13_lv_pmos w=1.27e-06 l=1.3e-07
MP5 n4 A Y VDD sg13_lv_pmos w=1.27e-06 l=1.3e-07
.ENDS

****************************************
* Cell : OAI222_DL
* Description : Inverted output OR-AND gate with three two-input OR gates
* Reduced truth table for output Y
* ┌─────┬─────┬─────┬─────┬─────┬─────┬─────┐
* │ A   │ B   │ C   │ D   │ E   │ F   │   Y │
* ├─────┼─────┼─────┼─────┼─────┼─────┼─────┤
* │ 0   │ 0   │ -   │ -   │ -   │ -   │   1 │
* ├─────┼─────┼─────┼─────┼─────┼─────┼─────┤
* │ -   │ -   │ 0   │ 0   │ -   │ -   │   1 │
* ├─────┼─────┼─────┼─────┼─────┼─────┼─────┤
* │ -   │ -   │ -   │ -   │ 0   │ 0   │   1 │
* ├─────┼─────┼─────┼─────┼─────┼─────┼─────┤
* │ 1   │ -   │ 1   │ -   │ 1   │ -   │   0 │
* ├─────┼─────┼─────┼─────┼─────┼─────┼─────┤
* │ 1   │ -   │ 1   │ -   │ -   │ 1   │   0 │
* ├─────┼─────┼─────┼─────┼─────┼─────┼─────┤
* │ 1   │ -   │ -   │ 1   │ 1   │ -   │   0 │
* ├─────┼─────┼─────┼─────┼─────┼─────┼─────┤
* │ 1   │ -   │ -   │ 1   │ -   │ 1   │   0 │
* ├─────┼─────┼─────┼─────┼─────┼─────┼─────┤
* │ -   │ 1   │ 1   │ -   │ 1   │ -   │   0 │
* ├─────┼─────┼─────┼─────┼─────┼─────┼─────┤
* │ -   │ 1   │ 1   │ -   │ -   │ 1   │   0 │
* ├─────┼─────┼─────┼─────┼─────┼─────┼─────┤
* │ -   │ 1   │ -   │ 1   │ 1   │ -   │   0 │
* ├─────┼─────┼─────┼─────┼─────┼─────┼─────┤
* │ -   │ 1   │ -   │ 1   │ -   │ 1   │   0 │
* └─────┴─────┴─────┴─────┴─────┴─────┴─────┘
****************************************
.SUBCKT OAI222_DL A B C D E F Y VDD VSS
*.PININFO A:I B:I C:I D:I E:I F:I Y:O VDD:B VSS:B
MN0 n0 F Y VSS sg13_lv_nmos w=6e-07 l=1.3e-07
MN1 n0 E Y VSS sg13_lv_nmos w=6e-07 l=1.3e-07
MN2 n1 A n0 VSS sg13_lv_nmos w=6e-07 l=1.3e-07
MN3 n1 B n0 VSS sg13_lv_nmos w=6e-07 l=1.3e-07
MN4 n1 D VSS VSS sg13_lv_nmos w=6e-07 l=1.3e-07
MN5 n1 C VSS VSS sg13_lv_nmos w=6e-07 l=1.3e-07
MP0 n2 F VDD VDD sg13_lv_pmos w=8e-07 l=1.3e-07
MP1 Y E n2 VDD sg13_lv_pmos w=8e-07 l=1.3e-07
MP2 n3 D VDD VDD sg13_lv_pmos w=8e-07 l=1.3e-07
MP3 Y C n3 VDD sg13_lv_pmos w=8e-07 l=1.3e-07
MP4 n4 B VDD VDD sg13_lv_pmos w=8e-07 l=1.3e-07
MP5 n4 A Y VDD sg13_lv_pmos w=8e-07 l=1.3e-07
.ENDS

****************************************
* Cell : OAI22_D1
* Description : Inverted output OR-AND gate with two two-input OR gates
* Reduced truth table for output Y
* ┌─────┬─────┬─────┬─────┬─────┐
* │ A   │ B   │ C   │ D   │   Y │
* ├─────┼─────┼─────┼─────┼─────┤
* │ 0   │ 0   │ -   │ -   │   1 │
* ├─────┼─────┼─────┼─────┼─────┤
* │ -   │ -   │ 0   │ 0   │   1 │
* ├─────┼─────┼─────┼─────┼─────┤
* │ 1   │ -   │ 1   │ -   │   0 │
* ├─────┼─────┼─────┼─────┼─────┤
* │ 1   │ -   │ -   │ 1   │   0 │
* ├─────┼─────┼─────┼─────┼─────┤
* │ -   │ 1   │ 1   │ -   │   0 │
* ├─────┼─────┼─────┼─────┼─────┤
* │ -   │ 1   │ -   │ 1   │   0 │
* └─────┴─────┴─────┴─────┴─────┘
****************************************
.SUBCKT OAI22_D1 A B C D Y VDD VSS
*.PININFO A:I B:I C:I D:I Y:O VDD:B VSS:B
MN0 n0 C VSS VSS sg13_lv_nmos w=9e-07 l=1.3e-07
MN1 n0 D VSS VSS sg13_lv_nmos w=9e-07 l=1.3e-07
MN2 n0 A Y VSS sg13_lv_nmos w=9e-07 l=1.3e-07
MN3 n0 B Y VSS sg13_lv_nmos w=9e-07 l=1.3e-07
MP0 n1 A VDD VDD sg13_lv_pmos w=1.27e-06 l=1.3e-07
MP1 n1 B Y VDD sg13_lv_pmos w=1.27e-06 l=1.3e-07
MP2 n2 C VDD VDD sg13_lv_pmos w=1.27e-06 l=1.3e-07
MP3 n2 D Y VDD sg13_lv_pmos w=1.27e-06 l=1.3e-07
.ENDS

****************************************
* Cell : OAI22_DL
* Description : Inverted output OR-AND gate with two two-input OR gates
* Reduced truth table for output Y
* ┌─────┬─────┬─────┬─────┬─────┐
* │ A   │ B   │ C   │ D   │   Y │
* ├─────┼─────┼─────┼─────┼─────┤
* │ 0   │ 0   │ -   │ -   │   1 │
* ├─────┼─────┼─────┼─────┼─────┤
* │ -   │ -   │ 0   │ 0   │   1 │
* ├─────┼─────┼─────┼─────┼─────┤
* │ 1   │ -   │ 1   │ -   │   0 │
* ├─────┼─────┼─────┼─────┼─────┤
* │ 1   │ -   │ -   │ 1   │   0 │
* ├─────┼─────┼─────┼─────┼─────┤
* │ -   │ 1   │ 1   │ -   │   0 │
* ├─────┼─────┼─────┼─────┼─────┤
* │ -   │ 1   │ -   │ 1   │   0 │
* └─────┴─────┴─────┴─────┴─────┘
****************************************
.SUBCKT OAI22_DL A B C D Y VDD VSS
*.PININFO A:I B:I C:I D:I Y:O VDD:B VSS:B
MN0 n0 C VSS VSS sg13_lv_nmos w=6e-07 l=1.3e-07
MN1 n0 D VSS VSS sg13_lv_nmos w=6e-07 l=1.3e-07
MN2 n0 A Y VSS sg13_lv_nmos w=6e-07 l=1.3e-07
MN3 n0 B Y VSS sg13_lv_nmos w=6e-07 l=1.3e-07
MP0 n1 A VDD VDD sg13_lv_pmos w=8.4e-07 l=1.3e-07
MP1 n1 B Y VDD sg13_lv_pmos w=8.4e-07 l=1.3e-07
MP2 n2 C VDD VDD sg13_lv_pmos w=8.4e-07 l=1.3e-07
MP3 n2 D Y VDD sg13_lv_pmos w=8.4e-07 l=1.3e-07
.ENDS

****************************************
* Cell : OR2_D1
* Description : Two input OR gate
* Reduced truth table for output Y
* ┌─────┬─────┬─────┐
* │ A   │ B   │   Y │
* ├─────┼─────┼─────┤
* │ 1   │ -   │   1 │
* ├─────┼─────┼─────┤
* │ -   │ 1   │   1 │
* ├─────┼─────┼─────┤
* │ 0   │ 0   │   0 │
* └─────┴─────┴─────┘
****************************************
.SUBCKT OR2_D1 A B Y VDD VSS
*.PININFO A:I B:I Y:O VDD:B VSS:B
MN0 n0 A VSS VSS sg13_lv_nmos w=2e-07 l=1.3e-07 ng=1
MN1 n0 B VSS VSS sg13_lv_nmos w=2e-07 l=1.3e-07 ng=1
MP0 n1 A VDD VDD sg13_lv_pmos w=4e-07 l=1.3e-07 ng=1
MP1 n0 B n1 VDD sg13_lv_pmos w=4e-07 l=1.3e-07 ng=1
MN2 Y n0 VSS VSS sg13_lv_nmos w=6.4e-07 l=1.3e-07 ng=1
MP2 Y n0 VDD VDD sg13_lv_pmos w=9.8e-07 l=1.3e-07 ng=1
.ENDS

****************************************
* Cell : OR2_D2
* Description : Two input OR gate
* Reduced truth table for output Y
* ┌─────┬─────┬─────┐
* │ A   │ B   │   Y │
* ├─────┼─────┼─────┤
* │ 1   │ -   │   1 │
* ├─────┼─────┼─────┤
* │ -   │ 1   │   1 │
* ├─────┼─────┼─────┤
* │ 0   │ 0   │   0 │
* └─────┴─────┴─────┘
****************************************
.SUBCKT OR2_D2 A B Y VDD VSS
*.PININFO A:I B:I Y:O VDD:B VSS:B
MN0 n0 B VSS VSS sg13_lv_nmos w=5e-07 l=1.3e-07 ng=1
MN1 n0 A VSS VSS sg13_lv_nmos w=5e-07 l=1.3e-07 ng=1
MP0 n1 B VDD VDD sg13_lv_pmos w=1e-06 l=1.3e-07 ng=1
MP1 n0 A n1 VDD sg13_lv_pmos w=1e-06 l=1.3e-07 ng=1
MN2 Y n0 VSS VSS sg13_lv_nmos w=1.07e-06 l=1.3e-07 ng=2
MP2 Y n0 VDD VDD sg13_lv_pmos w=1.6e-06 l=1.3e-07 ng=2
.ENDS

****************************************
* Cell : OR2_D4
* Description : Two input OR gate
* Reduced truth table for output Y
* ┌─────┬─────┬─────┐
* │ A   │ B   │   Y │
* ├─────┼─────┼─────┤
* │ 1   │ -   │   1 │
* ├─────┼─────┼─────┤
* │ -   │ 1   │   1 │
* ├─────┼─────┼─────┤
* │ 0   │ 0   │   0 │
* └─────┴─────┴─────┘
****************************************
.SUBCKT OR2_D4 A B Y VDD VSS
*.PININFO A:I B:I Y:O VDD:B VSS:B
MN0 n0 B VSS VSS sg13_lv_nmos w=8e-07 l=1.3e-07 ng=1
MN1 n0 A VSS VSS sg13_lv_nmos w=8e-07 l=1.3e-07 ng=1
MP0 n1 B VDD VDD sg13_lv_pmos w=1.5e-06 l=1.3e-07 ng=1
MP1 n0 A n1 VDD sg13_lv_pmos w=1.5e-06 l=1.3e-07 ng=1
MN2 Y n0 VSS VSS sg13_lv_nmos w=1.8e-06 l=1.3e-07 ng=2
MP2 Y n0 VDD VDD sg13_lv_pmos w=2.6e-06 l=1.3e-07 ng=2
.ENDS

****************************************
* Cell : OR2_DL
* Description : Two input OR gate
* Reduced truth table for output Y
* ┌─────┬─────┬─────┐
* │ A   │ B   │   Y │
* ├─────┼─────┼─────┤
* │ 1   │ -   │   1 │
* ├─────┼─────┼─────┤
* │ -   │ 1   │   1 │
* ├─────┼─────┼─────┤
* │ 0   │ 0   │   0 │
* └─────┴─────┴─────┘
****************************************
.SUBCKT OR2_DL A B Y VDD VSS
*.PININFO A:I B:I Y:O VDD:B VSS:B
MN0 n0 B VSS VSS sg13_lv_nmos w=1.5e-07 l=1.3e-07 ng=1
MN1 n0 A VSS VSS sg13_lv_nmos w=1.5e-07 l=1.3e-07 ng=1
MP0 n1 B VDD VDD sg13_lv_pmos w=3e-07 l=1.3e-07 ng=1
MP1 n0 A n1 VDD sg13_lv_pmos w=3e-07 l=1.3e-07 ng=1
MN2 Y n0 VSS VSS sg13_lv_nmos w=3.2e-07 l=1.3e-07 ng=1
MP2 Y n0 VDD VDD sg13_lv_pmos w=4.9e-07 l=1.3e-07 ng=1
.ENDS

****************************************
* Cell : OR3_D1
* Description : Three input OR gate
* Reduced truth table for output Y
* ┌─────┬─────┬─────┬─────┐
* │ A   │ B   │ C   │   Y │
* ├─────┼─────┼─────┼─────┤
* │ 1   │ -   │ -   │   1 │
* ├─────┼─────┼─────┼─────┤
* │ -   │ 1   │ -   │   1 │
* ├─────┼─────┼─────┼─────┤
* │ -   │ -   │ 1   │   1 │
* ├─────┼─────┼─────┼─────┤
* │ 0   │ 0   │ 0   │   0 │
* └─────┴─────┴─────┴─────┘
****************************************
.SUBCKT OR3_D1 A B C Y VDD VSS
*.PININFO A:I B:I C:I Y:O VDD:B VSS:B
MN0 n0 A VSS VSS sg13_lv_nmos w=2e-07 l=1.3e-07 ng=1
MN1 n0 B VSS VSS sg13_lv_nmos w=2e-07 l=1.3e-07 ng=1
MN2 n0 C VSS VSS sg13_lv_nmos w=2e-07 l=1.3e-07 ng=1
MP0 n1 A VDD VDD sg13_lv_pmos w=6e-07 l=1.3e-07 ng=1
MP1 n2 B n1 VDD sg13_lv_pmos w=6e-07 l=1.3e-07 ng=1
MP2 n0 C n2 VDD sg13_lv_pmos w=6e-07 l=1.3e-07 ng=1
MN3 Y n0 VSS VSS sg13_lv_nmos w=6.4e-07 l=1.3e-07 ng=1
MP3 Y n0 VDD VDD sg13_lv_pmos w=9.8e-07 l=1.3e-07 ng=1
.ENDS

****************************************
* Cell : OR3_D2
* Description : Three input OR gate
* Reduced truth table for output Y
* ┌─────┬─────┬─────┬─────┐
* │ A   │ B   │ C   │   Y │
* ├─────┼─────┼─────┼─────┤
* │ 1   │ -   │ -   │   1 │
* ├─────┼─────┼─────┼─────┤
* │ -   │ 1   │ -   │   1 │
* ├─────┼─────┼─────┼─────┤
* │ -   │ -   │ 1   │   1 │
* ├─────┼─────┼─────┼─────┤
* │ 0   │ 0   │ 0   │   0 │
* └─────┴─────┴─────┴─────┘
****************************************
.SUBCKT OR3_D2 A B C Y VDD VSS
*.PININFO A:I B:I C:I Y:O VDD:B VSS:B
MN0 n0 A VSS VSS sg13_lv_nmos w=5e-07 l=1.3e-07 ng=1
MN1 n0 B VSS VSS sg13_lv_nmos w=5e-07 l=1.3e-07 ng=1
MN2 n0 C VSS VSS sg13_lv_nmos w=5e-07 l=1.3e-07 ng=1
MP0 n1 A VDD VDD sg13_lv_pmos w=1.1e-06 l=1.3e-07 ng=1
MP1 n2 B n1 VDD sg13_lv_pmos w=1.1e-06 l=1.3e-07 ng=1
MP2 n0 C n2 VDD sg13_lv_pmos w=1.1e-06 l=1.3e-07 ng=1
MN3 Y n0 VSS VSS sg13_lv_nmos w=1.07e-06 l=1.3e-07 ng=2
MP3 Y n0 VDD VDD sg13_lv_pmos w=1.6e-06 l=1.3e-07 ng=2
.ENDS

****************************************
* Cell : OR3_D4
* Description : Three input OR gate
* Reduced truth table for output Y
* ┌─────┬─────┬─────┬─────┐
* │ A   │ B   │ C   │   Y │
* ├─────┼─────┼─────┼─────┤
* │ 1   │ -   │ -   │   1 │
* ├─────┼─────┼─────┼─────┤
* │ -   │ 1   │ -   │   1 │
* ├─────┼─────┼─────┼─────┤
* │ -   │ -   │ 1   │   1 │
* ├─────┼─────┼─────┼─────┤
* │ 0   │ 0   │ 0   │   0 │
* └─────┴─────┴─────┴─────┘
****************************************
.SUBCKT OR3_D4 A B C Y VDD VSS
*.PININFO A:I B:I C:I Y:O VDD:B VSS:B
MN0 n0 A VSS VSS sg13_lv_nmos w=8e-07 l=1.3e-07 ng=2
MN1 n0 B VSS VSS sg13_lv_nmos w=8e-07 l=1.3e-07 ng=2
MN2 n0 C VSS VSS sg13_lv_nmos w=8e-07 l=1.3e-07 ng=2
MP0 n1 A VDD VDD sg13_lv_pmos w=2.4e-06 l=1.3e-07 ng=2
MP1 n2 B n1 VDD sg13_lv_pmos w=2.4e-06 l=1.3e-07 ng=2
MP2 n0 C n2 VDD sg13_lv_pmos w=2.4e-06 l=1.3e-07 ng=2
MN3 Y n0 VSS VSS sg13_lv_nmos w=2.4e-06 l=1.3e-07 ng=3
MP3 Y n0 VDD VDD sg13_lv_pmos w=3.2e-06 l=1.3e-07 ng=3
.ENDS

****************************************
* Cell : OR3_DL
* Description : Three input OR gate
* Reduced truth table for output Y
* ┌─────┬─────┬─────┬─────┐
* │ A   │ B   │ C   │   Y │
* ├─────┼─────┼─────┼─────┤
* │ 1   │ -   │ -   │   1 │
* ├─────┼─────┼─────┼─────┤
* │ -   │ 1   │ -   │   1 │
* ├─────┼─────┼─────┼─────┤
* │ -   │ -   │ 1   │   1 │
* ├─────┼─────┼─────┼─────┤
* │ 0   │ 0   │ 0   │   0 │
* └─────┴─────┴─────┴─────┘
****************************************
.SUBCKT OR3_DL A B C Y VDD VSS
*.PININFO A:I B:I C:I Y:O VDD:B VSS:B
MN0 n0 A VSS VSS sg13_lv_nmos w=1.7e-07 l=1.3e-07 ng=1
MN1 n0 B VSS VSS sg13_lv_nmos w=1.7e-07 l=1.3e-07 ng=1
MN2 n0 C VSS VSS sg13_lv_nmos w=1.7e-07 l=1.3e-07 ng=1
MP0 n1 A VDD VDD sg13_lv_pmos w=5.1e-07 l=1.3e-07 ng=1
MP1 n2 B n1 VDD sg13_lv_pmos w=5.1e-07 l=1.3e-07 ng=1
MP2 n0 C n2 VDD sg13_lv_pmos w=5.1e-07 l=1.3e-07 ng=1
MN3 Y n0 VSS VSS sg13_lv_nmos w=3.2e-07 l=1.3e-07 ng=1
MP3 Y n0 VDD VDD sg13_lv_pmos w=4.9e-07 l=1.3e-07 ng=1
.ENDS

****************************************
* Cell : OR4_D1
* Description : Four input OR gate
* Reduced truth table for output Y
* ┌─────┬─────┬─────┬─────┬─────┐
* │ A   │ B   │ C   │ D   │   Y │
* ├─────┼─────┼─────┼─────┼─────┤
* │ 1   │ -   │ -   │ -   │   1 │
* ├─────┼─────┼─────┼─────┼─────┤
* │ -   │ 1   │ -   │ -   │   1 │
* ├─────┼─────┼─────┼─────┼─────┤
* │ -   │ -   │ 1   │ -   │   1 │
* ├─────┼─────┼─────┼─────┼─────┤
* │ -   │ -   │ -   │ 1   │   1 │
* ├─────┼─────┼─────┼─────┼─────┤
* │ 0   │ 0   │ 0   │ 0   │   0 │
* └─────┴─────┴─────┴─────┴─────┘
****************************************
.SUBCKT OR4_D1 A B C D Y VDD VSS
*.PININFO A:I B:I C:I D:I Y:O VDD:B VSS:B
MN0 n0 A VSS VSS sg13_lv_nmos w=2.2e-07 l=1.3e-07 ng=1
MN1 n0 B VSS VSS sg13_lv_nmos w=2.2e-07 l=1.3e-07 ng=1
MN2 n0 C VSS VSS sg13_lv_nmos w=2.2e-07 l=1.3e-07 ng=1
MN3 n0 D VSS VSS sg13_lv_nmos w=2.2e-07 l=1.3e-07 ng=1
MP0 n1 D VDD VDD sg13_lv_pmos w=6.6e-07 l=1.3e-07 ng=1
MP1 n2 C n1 VDD sg13_lv_pmos w=6.6e-07 l=1.3e-07 ng=1
MP2 n3 B n2 VDD sg13_lv_pmos w=6.6e-07 l=1.3e-07 ng=1
MP3 n0 A n3 VDD sg13_lv_pmos w=6.6e-07 l=1.3e-07 ng=1
MN4 Y n0 VSS VSS sg13_lv_nmos w=6.4e-07 l=1.3e-07 ng=1
MP4 Y n0 VDD VDD sg13_lv_pmos w=9.8e-07 l=1.3e-07 ng=1
.ENDS

****************************************
* Cell : OR4_D2
* Description : Four input OR gate
* Reduced truth table for output Y
* ┌─────┬─────┬─────┬─────┬─────┐
* │ A   │ B   │ C   │ D   │   Y │
* ├─────┼─────┼─────┼─────┼─────┤
* │ 1   │ -   │ -   │ -   │   1 │
* ├─────┼─────┼─────┼─────┼─────┤
* │ -   │ 1   │ -   │ -   │   1 │
* ├─────┼─────┼─────┼─────┼─────┤
* │ -   │ -   │ 1   │ -   │   1 │
* ├─────┼─────┼─────┼─────┼─────┤
* │ -   │ -   │ -   │ 1   │   1 │
* ├─────┼─────┼─────┼─────┼─────┤
* │ 0   │ 0   │ 0   │ 0   │   0 │
* └─────┴─────┴─────┴─────┴─────┘
****************************************
.SUBCKT OR4_D2 A B C D Y VDD VSS
*.PININFO A:I B:I C:I D:I Y:O VDD:B VSS:B
MN0 n0 A VSS VSS sg13_lv_nmos w=5e-07 l=1.3e-07 ng=1
MN1 n0 B VSS VSS sg13_lv_nmos w=5e-07 l=1.3e-07 ng=1
MN2 n0 C VSS VSS sg13_lv_nmos w=5e-07 l=1.3e-07 ng=1
MN3 n0 D VSS VSS sg13_lv_nmos w=5e-07 l=1.3e-07 ng=1
MP0 n1 D VDD VDD sg13_lv_pmos w=1.3e-06 l=1.3e-07 ng=1
MP1 n2 C n1 VDD sg13_lv_pmos w=1.3e-06 l=1.3e-07 ng=1
MP2 n3 B n2 VDD sg13_lv_pmos w=1.3e-06 l=1.3e-07 ng=1
MP3 n0 A n3 VDD sg13_lv_pmos w=1.3e-06 l=1.3e-07 ng=1
MN4 Y n0 VSS VSS sg13_lv_nmos w=1.07e-06 l=1.3e-07 ng=1
MP4 Y n0 VDD VDD sg13_lv_pmos w=1.6e-06 l=1.3e-07 ng=1
.ENDS

****************************************
* Cell : OR4_D4
* Description : Four input OR gate
* Reduced truth table for output Y
* ┌─────┬─────┬─────┬─────┬─────┐
* │ A   │ B   │ C   │ D   │   Y │
* ├─────┼─────┼─────┼─────┼─────┤
* │ 1   │ -   │ -   │ -   │   1 │
* ├─────┼─────┼─────┼─────┼─────┤
* │ -   │ 1   │ -   │ -   │   1 │
* ├─────┼─────┼─────┼─────┼─────┤
* │ -   │ -   │ 1   │ -   │   1 │
* ├─────┼─────┼─────┼─────┼─────┤
* │ -   │ -   │ -   │ 1   │   1 │
* ├─────┼─────┼─────┼─────┼─────┤
* │ 0   │ 0   │ 0   │ 0   │   0 │
* └─────┴─────┴─────┴─────┴─────┘
****************************************
.SUBCKT OR4_D4 A B C D Y VDD VSS
*.PININFO A:I B:I C:I D:I Y:O VDD:B VSS:B
MN0 n0 A VSS VSS sg13_lv_nmos w=9e-07 l=1.3e-07 ng=2
MN1 n0 B VSS VSS sg13_lv_nmos w=9e-07 l=1.3e-07 ng=2
MN2 n0 C VSS VSS sg13_lv_nmos w=9e-07 l=1.3e-07 ng=2
MN3 n0 D VSS VSS sg13_lv_nmos w=9e-07 l=1.3e-07 ng=2
MP0 n1 D VDD VDD sg13_lv_pmos w=2.7e-06 l=1.3e-07 ng=2
MP1 n2 C n1 VDD sg13_lv_pmos w=2.7e-06 l=1.3e-07 ng=2
MP2 n3 B n2 VDD sg13_lv_pmos w=2.7e-06 l=1.3e-07 ng=2
MP3 n0 A n3 VDD sg13_lv_pmos w=2.7e-06 l=1.3e-07 ng=2
MN4 Y n0 VSS VSS sg13_lv_nmos w=2.4e-06 l=1.3e-07 ng=3
MP4 Y n0 VDD VDD sg13_lv_pmos w=3.2e-06 l=1.3e-07 ng=3
.ENDS

****************************************
* Cell : OR4_DL
* Description : Four input OR gate
* Reduced truth table for output Y
* ┌─────┬─────┬─────┬─────┬─────┐
* │ A   │ B   │ C   │ D   │   Y │
* ├─────┼─────┼─────┼─────┼─────┤
* │ 1   │ -   │ -   │ -   │   1 │
* ├─────┼─────┼─────┼─────┼─────┤
* │ -   │ 1   │ -   │ -   │   1 │
* ├─────┼─────┼─────┼─────┼─────┤
* │ -   │ -   │ 1   │ -   │   1 │
* ├─────┼─────┼─────┼─────┼─────┤
* │ -   │ -   │ -   │ 1   │   1 │
* ├─────┼─────┼─────┼─────┼─────┤
* │ 0   │ 0   │ 0   │ 0   │   0 │
* └─────┴─────┴─────┴─────┴─────┘
****************************************
.SUBCKT OR4_DL A B C D Y VDD VSS
*.PININFO A:I B:I C:I D:I Y:O VDD:B VSS:B
MN0 n0 A VSS VSS sg13_lv_nmos w=1.9e-07 l=1.3e-07 ng=1
MN1 n0 B VSS VSS sg13_lv_nmos w=1.9e-07 l=1.3e-07 ng=1
MN2 n0 C VSS VSS sg13_lv_nmos w=1.9e-07 l=1.3e-07 ng=1
MN3 n0 D VSS VSS sg13_lv_nmos w=1.9e-07 l=1.3e-07 ng=1
MP0 n1 D VDD VDD sg13_lv_pmos w=5.7e-07 l=1.3e-07 ng=1
MP1 n2 C n1 VDD sg13_lv_pmos w=5.7e-07 l=1.3e-07 ng=1
MP2 n3 B n2 VDD sg13_lv_pmos w=5.7e-07 l=1.3e-07 ng=1
MP3 n0 A n3 VDD sg13_lv_pmos w=5.7e-07 l=1.3e-07 ng=1
MN4 Y n0 VSS VSS sg13_lv_nmos w=3.2e-07 l=1.3e-07 ng=1
MP4 Y n0 VDD VDD sg13_lv_pmos w=4.9e-07 l=1.3e-07 ng=1
.ENDS

****************************************
* Cell : TIEH
* Description : Tie high cell - constant logic '1'.
* Reduced truth table for output Y
* ┌─────┐
* │   Y │
* ├─────┤
* │   1 │
* └─────┘
****************************************
.SUBCKT TIEH Y VDD VSS
*.PININFO Y:O VDD:B VSS:B
MN0 n0 n0 VSS VSS sg13_lv_nmos w=3.2e-07 l=1.3e-07
MP0 Y n0 VDD VDD sg13_lv_pmos w=1.2e-06 l=1.3e-07
.ENDS

****************************************
* Cell : TIEL
* Description : Tie low cell - constant logic '0'.
* Reduced truth table for output Y
* ┌─────┐
* │   Y │
* ├─────┤
* │   0 │
* └─────┘
****************************************
.SUBCKT TIEL Y VDD VSS
*.PININFO Y:O VDD:B VSS:B
MN0 Y n0 VSS VSS sg13_lv_nmos w=6.4e-07 l=1.3e-07
MP0 n0 n0 VDD VDD sg13_lv_pmos w=6.4e-07 l=1.3e-07
.ENDS

****************************************
* Cell : XNOR2_D1
* Description : Two input exclusive NOR.
* Reduced truth table for output Y
* ┌─────┬─────┬─────┐
* │   A │   B │   Y │
* ├─────┼─────┼─────┤
* │   1 │   1 │   1 │
* ├─────┼─────┼─────┤
* │   0 │   0 │   1 │
* ├─────┼─────┼─────┤
* │   0 │   1 │   0 │
* ├─────┼─────┼─────┤
* │   1 │   0 │   0 │
* └─────┴─────┴─────┘
****************************************
.SUBCKT XNOR2_D1 A B Y VDD VSS
*.PININFO A:I B:I Y:O VDD:B VSS:B
MN0 n0 n1 VSS VSS sg13_lv_nmos w=5e-07 l=1.3e-07 ng=1
MP0 n0 n1 VDD VDD sg13_lv_pmos w=8e-07 l=1.3e-07 ng=1
MN1 n1 B VSS VSS sg13_lv_nmos w=5e-07 l=1.3e-07 ng=1
MP1 n1 B VDD VDD sg13_lv_pmos w=8e-07 l=1.3e-07 ng=1
MN2 n2 A VSS VSS sg13_lv_nmos w=2e-07 l=1.3e-07 ng=1
MP2 n2 A VDD VDD sg13_lv_pmos w=3e-07 l=1.3e-07 ng=1
MN3 n1 n2 Y VSS sg13_lv_nmos w=5e-07 l=1.3e-07
MN4 n0 A Y VSS sg13_lv_nmos w=5e-07 l=1.3e-07
MP3 n1 A Y VDD sg13_lv_pmos w=8e-07 l=1.3e-07
MP4 n0 n2 Y VDD sg13_lv_pmos w=8e-07 l=1.3e-07
.ENDS

****************************************
* Cell : XNOR2_DL
* Description : Two input exclusive NOR.
* Reduced truth table for output Y
* ┌─────┬─────┬─────┐
* │   A │   B │   Y │
* ├─────┼─────┼─────┤
* │   1 │   1 │   1 │
* ├─────┼─────┼─────┤
* │   0 │   0 │   1 │
* ├─────┼─────┼─────┤
* │   0 │   1 │   0 │
* ├─────┼─────┼─────┤
* │   1 │   0 │   0 │
* └─────┴─────┴─────┘
****************************************
.SUBCKT XNOR2_DL A B Y VDD VSS
*.PININFO A:I B:I Y:O VDD:B VSS:B
MN0 n0 n1 VSS VSS sg13_lv_nmos w=3e-07 l=1.3e-07 ng=1
MP0 n0 n1 VDD VDD sg13_lv_pmos w=4e-07 l=1.3e-07 ng=1
MN1 n1 B VSS VSS sg13_lv_nmos w=3e-07 l=1.3e-07 ng=1
MP1 n1 B VDD VDD sg13_lv_pmos w=4e-07 l=1.3e-07 ng=1
MN2 n2 A VSS VSS sg13_lv_nmos w=2e-07 l=1.3e-07 ng=1
MP2 n2 A VDD VDD sg13_lv_pmos w=3e-07 l=1.3e-07 ng=1
MN3 n1 n2 Y VSS sg13_lv_nmos w=2e-07 l=1.3e-07
MN4 n0 A Y VSS sg13_lv_nmos w=2e-07 l=1.3e-07
MP3 n1 A Y VDD sg13_lv_pmos w=3e-07 l=1.3e-07
MP4 n0 n2 Y VDD sg13_lv_pmos w=3e-07 l=1.3e-07
.ENDS

****************************************
* Cell : XOR2_D1
* Description : Two input exclusive OR.
* Reduced truth table for output Y
* ┌─────┬─────┬─────┐
* │   A │   B │   Y │
* ├─────┼─────┼─────┤
* │   1 │   0 │   1 │
* ├─────┼─────┼─────┤
* │   0 │   1 │   1 │
* ├─────┼─────┼─────┤
* │   0 │   0 │   0 │
* ├─────┼─────┼─────┤
* │   1 │   1 │   0 │
* └─────┴─────┴─────┘
****************************************
.SUBCKT XOR2_D1 A B Y VDD VSS
*.PININFO A:I B:I Y:O VDD:B VSS:B
MN0 n0 n1 VSS VSS sg13_lv_nmos w=5e-07 l=1.3e-07 ng=1
MP0 n0 n1 VDD VDD sg13_lv_pmos w=8e-07 l=1.3e-07 ng=1
MN1 n1 B VSS VSS sg13_lv_nmos w=5e-07 l=1.3e-07 ng=1
MP1 n1 B VDD VDD sg13_lv_pmos w=8e-07 l=1.3e-07 ng=1
MN2 n2 A VSS VSS sg13_lv_nmos w=2e-07 l=1.3e-07 ng=1
MP2 n2 A VDD VDD sg13_lv_pmos w=3e-07 l=1.3e-07 ng=1
MN3 n1 A Y VSS sg13_lv_nmos w=5e-07 l=1.3e-07
MN4 n0 n2 Y VSS sg13_lv_nmos w=5e-07 l=1.3e-07
MP3 n1 n2 Y VDD sg13_lv_pmos w=8e-07 l=1.3e-07
MP4 n0 A Y VDD sg13_lv_pmos w=8e-07 l=1.3e-07
.ENDS

****************************************
* Cell : XOR2_DL
* Description : Two input exclusive OR.
* Reduced truth table for output Y
* ┌─────┬─────┬─────┐
* │   A │   B │   Y │
* ├─────┼─────┼─────┤
* │   1 │   0 │   1 │
* ├─────┼─────┼─────┤
* │   0 │   1 │   1 │
* ├─────┼─────┼─────┤
* │   0 │   0 │   0 │
* ├─────┼─────┼─────┤
* │   1 │   1 │   0 │
* └─────┴─────┴─────┘
****************************************
.SUBCKT XOR2_DL A B Y VDD VSS
*.PININFO A:I B:I Y:O VDD:B VSS:B
MN0 n0 n1 VSS VSS sg13_lv_nmos w=3e-07 l=1.3e-07 ng=1
MP0 n0 n1 VDD VDD sg13_lv_pmos w=4e-07 l=1.3e-07 ng=1
MN1 n1 B VSS VSS sg13_lv_nmos w=3e-07 l=1.3e-07 ng=1
MP1 n1 B VDD VDD sg13_lv_pmos w=4e-07 l=1.3e-07 ng=1
MN2 n2 A VSS VSS sg13_lv_nmos w=2e-07 l=1.3e-07 ng=1
MP2 n2 A VDD VDD sg13_lv_pmos w=3e-07 l=1.3e-07 ng=1
MN3 n1 A Y VSS sg13_lv_nmos w=2e-07 l=1.3e-07
MN4 n0 n2 Y VSS sg13_lv_nmos w=2e-07 l=1.3e-07
MP3 n1 n2 Y VDD sg13_lv_pmos w=3e-07 l=1.3e-07
MP4 n0 A Y VDD sg13_lv_pmos w=3e-07 l=1.3e-07
.ENDS
